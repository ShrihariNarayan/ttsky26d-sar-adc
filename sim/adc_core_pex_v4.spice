* adc_core_pex.spice -- post-layout (C-only PEX, Magic) netlist of the full tile analog core,
* generated from tt_um_shriharinarayan_sar_adc by mk_core.py. Pin order = xschem adc_core.
* NGSPICE file created from tt_um_shriharinarayan_sar_adc.ext - technology: sky130A

.subckt sky130_fd_pr__nfet_01v8_34VMYE B D S G
X0 S G D B sky130_fd_pr__nfet_01v8 ad=0.29 pd=2.58 as=0.29 ps=2.58 w=1 l=0.15
C0 D S 0.08701f
C1 G S 0.02676f
C2 G D 0.02676f
C3 S B 0.25019f
C4 D B 0.25019f
.ends

.subckt sky130_fd_pr__nfet_01v8_JSF6K7 B D S G
X0 S G D B sky130_fd_pr__nfet_01v8 ad=1.16 pd=8.58 as=1.16 ps=8.58 w=4 l=0.15
C0 D S 0.3443f
C1 G S 0.06815f
C2 G D 0.06815f
C3 S B 0.47525f
C4 D B 0.47525f
.ends

.subckt sky130_fd_pr__pfet_01v8_7HN6Y2 B D S G VSUBS
X0 S G D B sky130_fd_pr__pfet_01v8 ad=0.29 pd=2.58 as=0.29 ps=2.58 w=1 l=0.15
C0 G D 0.02568f
C1 B D 0.06826f
C2 D S 0.08701f
C3 B G 0.22722f
C4 G S 0.02568f
C5 B S 0.06826f
C6 S VSUBS 0.08163f
C7 D VSUBS 0.08163f
C8 B VSUBS 1.13906f
.ends

.subckt sky130_fd_pr__pfet_01v8_VJT448 B D S G VSUBS
X0 S G D B sky130_fd_pr__pfet_01v8 ad=0.58 pd=4.58 as=0.58 ps=4.58 w=2 l=0.15
C0 G D 0.04023f
C1 B D 0.12129f
C2 D S 0.17277f
C3 B G 0.23095f
C4 G S 0.04023f
C5 B S 0.12129f
C6 S VSUBS 0.10779f
C7 D VSUBS 0.10779f
C8 B VSUBS 1.46341f
.ends

.subckt sky130_fd_pr__nfet_01v8_NK2ZG9 B D S G
X0 S G D B sky130_fd_pr__nfet_01v8 ad=0.58 pd=4.58 as=0.58 ps=4.58 w=2 l=0.15
C0 D S 0.17277f
C1 G S 0.0414f
C2 G D 0.0414f
C3 S B 0.32587f
C4 D B 0.32587f
.ends

.subckt sky130_fd_pr__cap_mim_m3_1_QUBC75 C2 C1 VSUBS
X0 C1 C2 sky130_fd_pr__cap_mim_m3_1 l=11 w=11
X1 C1 C2 sky130_fd_pr__cap_mim_m3_1 l=11 w=11
C0 C2 C1 22.5661f
C1 C2 VSUBS 9.82634f
.ends

.subckt bootstrap_switch phi vin vout M9/G M9/D MIP/D M8/G M8/S VDD VSS
XM10 VSS M14/S VSS MIP/D sky130_fd_pr__nfet_01v8_34VMYE
XM11 VSS vin vout M9/G sky130_fd_pr__nfet_01v8_34VMYE
XM12 VSS VSS M9/D MIP/D sky130_fd_pr__nfet_01v8_34VMYE
XM14 VSS M9/G M14/S VDD sky130_fd_pr__nfet_01v8_JSF6K7
XM15 VSS M8/G M9/D phi sky130_fd_pr__nfet_01v8_34VMYE
XM16 VDD M8/G VDD phi VSS sky130_fd_pr__pfet_01v8_7HN6Y2
XMIN VSS MIP/D VSS phi sky130_fd_pr__nfet_01v8_34VMYE
XM3 M8/S M8/S VDD M9/G VSS sky130_fd_pr__pfet_01v8_VJT448
XMIP VDD MIP/D VDD phi VSS sky130_fd_pr__pfet_01v8_VJT448
XM8 M8/S M9/G M8/S M8/G VSS sky130_fd_pr__pfet_01v8_VJT448
XM9 VSS M9/D vin M9/G sky130_fd_pr__nfet_01v8_NK2ZG9
XC2 M9/D M8/S VSS sky130_fd_pr__cap_mim_m3_1_QUBC75
C0 vin vout 0.02333f
C1 MIP/D M9/G 0.01865f
C2 phi M9/G 0.62528f
C3 VDD M14/S 0.03539f
C4 VDD M8/S 0.31139f
C5 VDD MIP/D 0.23362f
C6 VDD phi 0.45297f
C7 M9/D M9/G 0.08006f
C8 MIP/D M14/S 0.41663f
C9 VDD M9/D 0.02585f
C10 phi M14/S 0.02116f
C11 M8/S phi 0.13512f
C12 vin M9/G 0.08072f
C13 phi MIP/D 0.15759f
C14 M8/G M9/G 0.31053f
C15 M8/S M9/D 0.30946f
C16 M8/G VDD 0.2697f
C17 phi M9/D 0.13792f
C18 M8/G M8/S 0.34008f
C19 VDD M9/G 0.4759f
C20 M8/G phi 0.20328f
C21 vin M9/D 0.05376f
C22 M9/G M14/S 0.09618f
C23 M8/S M9/G 0.45599f
C24 M8/G M9/D 0.29653f
C25 VDD VSS 0.4137f
C26 vin VSS 0.69586f
C27 M8/S VSS 0.39355f
C28 MIP/D VSS 2.42943f
C29 phi VSS 1.62164f
C30 M8/G VSS 1.14838f
C31 M9/D VSS 1.90668f
C32 M14/S VSS 0.71207f
C33 M9/G VSS 1.83168f
C34 vout VSS 0.05157f
.ends

.subckt sky130_fd_pr__cap_mim_m3_1_LFDY3D C2 C1 VSUBS
X0 C1 C2 sky130_fd_pr__cap_mim_m3_1 l=30 w=30
C0 C1 C2 78.2652f
C1 C2 VSUBS 21.49611f
.ends

.subckt sky130_fd_pr__nfet_01v8_5K744B B D0 G0 S1 G1 D2 G2 S3 G3 D4 G4 S5 G5 a_3145_n1000#
X0 a_3145_n1000# G5 S5 B sky130_fd_pr__nfet_01v8 ad=2.9 pd=20.58 as=1.45 ps=10.29 w=10 l=5
X1 D4 G3 S3 B sky130_fd_pr__nfet_01v8 ad=1.45 pd=10.29 as=1.45 ps=10.29 w=10 l=5
X2 S1 G0 D0 B sky130_fd_pr__nfet_01v8 ad=1.45 pd=10.29 as=2.9 ps=20.58 w=10 l=5
X3 S3 G2 D2 B sky130_fd_pr__nfet_01v8 ad=1.45 pd=10.29 as=1.45 ps=10.29 w=10 l=5
X4 S5 G4 D4 B sky130_fd_pr__nfet_01v8 ad=1.45 pd=10.29 as=1.45 ps=10.29 w=10 l=5
X5 D2 G1 S1 B sky130_fd_pr__nfet_01v8 ad=1.45 pd=10.29 as=1.45 ps=10.29 w=10 l=5
C0 G4 D4 0.84307f
C1 G0 D0 0.84307f
C2 G4 G5 0.05269f
C3 S1 D2 0.06802f
C4 G2 G1 0.05269f
C5 G0 G1 0.05269f
C6 a_3145_n1000# S5 0.06802f
C7 S3 G3 0.84307f
C8 G3 G2 0.05269f
C9 G0 S1 0.84307f
C10 S5 D4 0.06802f
C11 G3 D4 0.84307f
C12 S5 G4 0.84307f
C13 G3 G4 0.05269f
C14 S5 G5 0.84307f
C15 S3 D2 0.06802f
C16 G2 D2 0.84307f
C17 S1 D0 0.06802f
C18 S1 G1 0.84307f
C19 S3 G2 0.84307f
C20 S3 D4 0.06802f
C21 a_3145_n1000# G5 0.84307f
C22 D2 G1 0.84307f
C23 S5 B 2.03595f
C24 D4 B 2.00106f
C25 S3 B 2.00084f
C26 D2 B 2.00106f
C27 S1 B 2.03595f
C28 D0 B 1.80064f
C29 a_3145_n1000# B 1.80064f
.ends

.subckt decap2 vcm VSSB Vref VSS
XCV0 VSSB vcm VSS sky130_fd_pr__cap_mim_m3_1_LFDY3D
XCV1 VSSB vcm VSS sky130_fd_pr__cap_mim_m3_1_LFDY3D
XCV2 VSSB vcm VSS sky130_fd_pr__cap_mim_m3_1_LFDY3D
XMD0 VSS VSS Vref VSS Vref VSS Vref VSS Vref VSS Vref VSS Vref VSS sky130_fd_pr__nfet_01v8_5K744B
XMD1 VSS VSS Vref VSS Vref VSS Vref VSS Vref VSS Vref VSS Vref VSS sky130_fd_pr__nfet_01v8_5K744B
XMD2 VSS VSS Vref VSS Vref VSS Vref VSS Vref VSS Vref VSS Vref VSS sky130_fd_pr__nfet_01v8_5K744B
XMD4 VSS VSS Vref VSS Vref VSS Vref VSS Vref VSS Vref VSS Vref VSS sky130_fd_pr__nfet_01v8_5K744B
XMD3 VSS VSS Vref VSS Vref VSS Vref VSS Vref VSS Vref VSS Vref VSS sky130_fd_pr__nfet_01v8_5K744B
XMD5 VSS VSS Vref VSS Vref VSS Vref VSS Vref VSS Vref VSS Vref VSS sky130_fd_pr__nfet_01v8_5K744B
XMD6 VSS VSS Vref VSS Vref VSS Vref VSS Vref VSS Vref VSS Vref VSS sky130_fd_pr__nfet_01v8_5K744B
XMD7 VSS VSS Vref VSS Vref VSS Vref VSS Vref VSS Vref VSS Vref VSS sky130_fd_pr__nfet_01v8_5K744B
XMD8 VSS VSS Vref VSS Vref VSS Vref VSS Vref VSS Vref VSS Vref VSS sky130_fd_pr__nfet_01v8_5K744B
XMD9 VSS VSS Vref VSS Vref VSS Vref VSS Vref VSS Vref VSS Vref VSS sky130_fd_pr__nfet_01v8_5K744B
C0 VSSB vcm 0.36405f
C1 Vref VSSB 69.33811f
C2 Vref vcm 6.94261f
C3 Vref VSS 16.22182f
C4 vcm VSS 6.07362f
C5 VSSB VSS 61.91421f
.ends

.subckt sky130_fd_pr__pfet_01v8_lvt_TEQ27F B D S G VSUBS
X0 S G D B sky130_fd_pr__pfet_01v8_lvt ad=0.29 pd=2.58 as=0.29 ps=2.58 w=1 l=0.35
C0 B G 0.2243f
C1 G S 0.02786f
C2 G D 0.02786f
C3 B S 0.0758f
C4 B D 0.0758f
C5 D S 0.06058f
C6 S VSUBS 0.08159f
C7 D VSUBS 0.08159f
C8 B VSUBS 1.22649f
.ends

.subckt sky130_fd_pr__nfet_01v8_PHAC7Z B D S G
X0 S G D B sky130_fd_pr__nfet_01v8 ad=0.145 pd=1.58 as=0.145 ps=1.58 w=0.5 l=0.15
C0 G D 0.0184f
C1 D S 0.04413f
C2 G S 0.0184f
C3 S B 0.21137f
C4 D B 0.21137f
.ends

.subckt sky130_fd_pr__pfet_01v8_lvt_DQLGWQ B D S G VSUBS
X0 S G D B sky130_fd_pr__pfet_01v8_lvt ad=1.16 pd=8.58 as=1.16 ps=8.58 w=4 l=0.35
C0 B G 0.22873f
C1 G S 0.10872f
C2 G D 0.10872f
C3 B S 0.246f
C4 B D 0.246f
C5 D S 0.23983f
C6 S VSUBS 0.15438f
C7 D VSUBS 0.15438f
C8 B VSUBS 2.27054f
.ends

.subckt sky130_fd_pr__pfet_01v8_lvt_EXY38E B D0 G0 S1 G1 a_99_n400# VSUBS
X0 a_99_n400# G1 S1 B sky130_fd_pr__pfet_01v8_lvt ad=1.16 pd=8.58 as=0.58 ps=4.29 w=4 l=0.35
X1 S1 G0 D0 B sky130_fd_pr__pfet_01v8_lvt ad=0.58 pd=4.29 as=1.16 ps=8.58 w=4 l=0.35
C0 a_99_n400# B 0.246f
C1 B G1 0.19252f
C2 B G0 0.19252f
C3 B S1 0.08953f
C4 D0 G0 0.10872f
C5 S1 D0 0.23983f
C6 a_99_n400# G1 0.10872f
C7 G0 G1 0.05517f
C8 a_99_n400# S1 0.23983f
C9 S1 G1 0.10872f
C10 B D0 0.246f
C11 S1 G0 0.10872f
C12 S1 VSUBS 0.06111f
C13 D0 VSUBS 0.14023f
C14 B VSUBS 2.784f
C15 a_99_n400# VSUBS 0.14023f
.ends

.subckt sky130_fd_pr__pfet_01v8_lvt_65C8BA B D0 G0 S1 G1 D2 G2 S3 G3 a_227_n400# VSUBS
X0 S1 G0 D0 B sky130_fd_pr__pfet_01v8_lvt ad=0.58 pd=4.29 as=1.16 ps=8.58 w=4 l=0.35
X1 a_227_n400# G3 S3 B sky130_fd_pr__pfet_01v8_lvt ad=1.16 pd=8.58 as=0.58 ps=4.29 w=4 l=0.35
X2 S3 G2 D2 B sky130_fd_pr__pfet_01v8_lvt ad=0.58 pd=4.29 as=0.58 ps=4.29 w=4 l=0.35
X3 D2 G1 S1 B sky130_fd_pr__pfet_01v8_lvt ad=0.58 pd=4.29 as=0.58 ps=4.29 w=4 l=0.35
C0 B D0 0.246f
C1 D2 G1 0.10872f
C2 a_227_n400# B 0.246f
C3 a_227_n400# S3 0.23983f
C4 B G1 0.15546f
C5 D2 S1 0.23983f
C6 B G0 0.19133f
C7 B S1 0.08953f
C8 B G3 0.19133f
C9 S3 G3 0.10872f
C10 G2 G1 0.05517f
C11 G3 G2 0.05517f
C12 D0 G0 0.10872f
C13 S1 D0 0.23983f
C14 D2 B 0.08953f
C15 D2 S3 0.23983f
C16 B S3 0.08953f
C17 G0 G1 0.05517f
C18 S1 G1 0.10872f
C19 a_227_n400# G3 0.10872f
C20 S1 G0 0.10872f
C21 D2 G2 0.10872f
C22 B G2 0.15546f
C23 S3 G2 0.10872f
C24 S3 VSUBS 0.04695f
C25 D2 VSUBS 0.0328f
C26 S1 VSUBS 0.04695f
C27 D0 VSUBS 0.14023f
C28 B VSUBS 3.81442f
C29 a_227_n400# VSUBS 0.14023f
.ends

.subckt sky130_fd_pr__nfet_01v8_ZXU89W B D0 G0 S1 G1 a_63_n400#
X0 a_63_n400# G1 S1 B sky130_fd_pr__nfet_01v8 ad=1.24 pd=8.62 as=0.66 ps=4.33 w=4 l=0.15
X1 S1 G0 D0 B sky130_fd_pr__nfet_01v8 ad=0.66 pd=4.33 as=1.24 ps=8.62 w=4 l=0.15
C0 G1 S1 0.05779f
C1 G0 D0 0.05779f
C2 a_63_n400# G1 0.05779f
C3 D0 S1 0.32431f
C4 G0 S1 0.05779f
C5 a_63_n400# S1 0.32431f
C6 S1 B 0.1906f
C7 D0 B 0.41609f
C8 a_63_n400# B 0.41609f
.ends

.subckt sky130_fd_pr__pfet_01v8_lvt_HGBDVL B D0 G0 S1 G1 D2 G2 S3 G3 D4 G4 S5 G5 D6
+ G6 S7 G7 a_483_n400# VSUBS
X0 S3 G2 D2 B sky130_fd_pr__pfet_01v8_lvt ad=0.58 pd=4.29 as=0.58 ps=4.29 w=4 l=0.35
X1 D6 G5 S5 B sky130_fd_pr__pfet_01v8_lvt ad=0.58 pd=4.29 as=0.58 ps=4.29 w=4 l=0.35
X2 D2 G1 S1 B sky130_fd_pr__pfet_01v8_lvt ad=0.58 pd=4.29 as=0.58 ps=4.29 w=4 l=0.35
X3 S5 G4 D4 B sky130_fd_pr__pfet_01v8_lvt ad=0.58 pd=4.29 as=0.58 ps=4.29 w=4 l=0.35
X4 S7 G6 D6 B sky130_fd_pr__pfet_01v8_lvt ad=0.58 pd=4.29 as=0.58 ps=4.29 w=4 l=0.35
X5 a_483_n400# G7 S7 B sky130_fd_pr__pfet_01v8_lvt ad=1.16 pd=8.58 as=0.58 ps=4.29 w=4 l=0.35
X6 D4 G3 S3 B sky130_fd_pr__pfet_01v8_lvt ad=0.58 pd=4.29 as=0.58 ps=4.29 w=4 l=0.35
X7 S1 G0 D0 B sky130_fd_pr__pfet_01v8_lvt ad=0.58 pd=4.29 as=1.16 ps=8.58 w=4 l=0.35
C0 S3 G2 0.10872f
C1 a_483_n400# S7 0.23983f
C2 D2 G2 0.10872f
C3 B G2 0.154f
C4 S7 B 0.08953f
C5 D2 S1 0.23983f
C6 S1 B 0.08953f
C7 D6 S7 0.23983f
C8 S3 G3 0.10872f
C9 G0 G1 0.05517f
C10 B G3 0.15376f
C11 S5 B 0.08953f
C12 S3 D4 0.23983f
C13 D6 S5 0.23983f
C14 G1 G2 0.05517f
C15 S1 G1 0.10872f
C16 B D4 0.08953f
C17 B G5 0.154f
C18 S7 G6 0.10872f
C19 B G4 0.15376f
C20 D6 G5 0.10872f
C21 G0 S1 0.10872f
C22 B D0 0.246f
C23 a_483_n400# G7 0.10872f
C24 B G7 0.19095f
C25 G5 G6 0.05517f
C26 G3 G2 0.05517f
C27 D2 S3 0.23983f
C28 S3 B 0.08953f
C29 a_483_n400# B 0.246f
C30 D2 B 0.08953f
C31 G6 G7 0.05517f
C32 D6 B 0.08953f
C33 G0 D0 0.10872f
C34 G3 D4 0.10872f
C35 S5 D4 0.23983f
C36 S5 G5 0.10872f
C37 S1 D0 0.23983f
C38 D2 G1 0.10872f
C39 G1 B 0.15478f
C40 G3 G4 0.05517f
C41 S5 G4 0.10872f
C42 S7 G7 0.10872f
C43 B G6 0.15478f
C44 D6 G6 0.10872f
C45 G0 B 0.19095f
C46 D4 G4 0.10872f
C47 G5 G4 0.05517f
C48 S7 VSUBS 0.04695f
C49 D6 VSUBS 0.0328f
C50 S5 VSUBS 0.0328f
C51 D4 VSUBS 0.0328f
C52 S3 VSUBS 0.0328f
C53 D2 VSUBS 0.0328f
C54 S1 VSUBS 0.04695f
C55 D0 VSUBS 0.14023f
C56 B VSUBS 5.88006f
C57 a_483_n400# VSUBS 0.14023f
.ends

.subckt sky130_fd_pr__nfet_01v8_TB4QGU B D0 G0 S1 G1 D2 G2 S3 G3 a_159_n400#
X0 S3 G2 D2 B sky130_fd_pr__nfet_01v8 ad=0.66 pd=4.33 as=0.66 ps=4.33 w=4 l=0.15
X1 S1 G0 D0 B sky130_fd_pr__nfet_01v8 ad=0.66 pd=4.33 as=1.24 ps=8.62 w=4 l=0.15
X2 D2 G1 S1 B sky130_fd_pr__nfet_01v8 ad=0.66 pd=4.33 as=0.66 ps=4.33 w=4 l=0.15
X3 a_159_n400# G3 S3 B sky130_fd_pr__nfet_01v8 ad=1.24 pd=8.62 as=0.66 ps=4.33 w=4 l=0.15
C0 G0 S1 0.05779f
C1 G1 G3 0.01248f
C2 D0 S1 0.32431f
C3 a_159_n400# G3 0.05779f
C4 S3 G3 0.05779f
C5 G0 G2 0.01248f
C6 G1 S1 0.05779f
C7 D2 S1 0.32431f
C8 D2 G1 0.05779f
C9 D2 S3 0.32431f
C10 G2 D2 0.05779f
C11 a_159_n400# S3 0.32431f
C12 G2 S3 0.05779f
C13 G0 D0 0.05779f
C14 S3 B 0.16676f
C15 D2 B 0.1611f
C16 S1 B 0.16676f
C17 D0 B 0.407f
C18 a_159_n400# B 0.407f
.ends

.subckt cdac dn2 dn5 dn6 dn7 vtop VDD dn4 MP7/D6 MN5/D dn1 dn3 MP6/D2 Vref dn0 VSS
XMP0 Vref MP0/D Vref dn0 VSS sky130_fd_pr__pfet_01v8_lvt_TEQ27F
XMP1 Vref MP1/D Vref dn1 VSS sky130_fd_pr__pfet_01v8_lvt_TEQ27F
XMN0 VSS MP0/D VSS dn0 sky130_fd_pr__nfet_01v8_PHAC7Z
XMP2 Vref MP2/D Vref dn2 VSS sky130_fd_pr__pfet_01v8_lvt_TEQ27F
XMN1 VSS MP1/D VSS dn1 sky130_fd_pr__nfet_01v8_PHAC7Z
XMP3 Vref MP3/D Vref dn3 VSS sky130_fd_pr__pfet_01v8_lvt_TEQ27F
XMN2 VSS MP2/D VSS dn2 sky130_fd_pr__nfet_01v8_PHAC7Z
XMP4 Vref MP4/D Vref dn4 VSS sky130_fd_pr__pfet_01v8_lvt_DQLGWQ
XMN3 VSS MP3/D VSS dn3 sky130_fd_pr__nfet_01v8_PHAC7Z
XMP5 Vref MN5/D dn5 Vref dn5 MN5/D VSS sky130_fd_pr__pfet_01v8_lvt_EXY38E
XMP6 Vref MP6/D2 dn6 Vref dn6 MP6/D2 dn6 Vref dn6 MP6/D2 VSS sky130_fd_pr__pfet_01v8_lvt_65C8BA
XMN4 VSS MP4/D VSS dn4 sky130_fd_pr__nfet_01v8_NK2ZG9
XMN5 VSS MN5/D VSS dn5 sky130_fd_pr__nfet_01v8_JSF6K7
XMN6 VSS MP6/D2 dn6 VSS dn6 MP6/D2 sky130_fd_pr__nfet_01v8_ZXU89W
XMP7 Vref MP7/D6 dn7 Vref dn7 MP7/D6 dn7 Vref dn7 MP7/D6 dn7 Vref dn7 MP7/D6 dn7 Vref
+ dn7 MP7/D6 VSS sky130_fd_pr__pfet_01v8_lvt_HGBDVL
XMN7 VSS MP7/D6 dn7 VSS dn7 MP7/D6 dn7 VSS dn7 MP7/D6 sky130_fd_pr__nfet_01v8_TB4QGU
X0 vtop MN5/D sky130_fd_pr__cap_mim_m3_1 l=2 w=2
X1 vtop MP3/D sky130_fd_pr__cap_mim_m3_1 l=2 w=2
X2 vtop MP6/D2 sky130_fd_pr__cap_mim_m3_1 l=2 w=2
X3 vtop MP7/D6 sky130_fd_pr__cap_mim_m3_1 l=2 w=2
X4 vtop MN5/D sky130_fd_pr__cap_mim_m3_1 l=2 w=2
X5 vtop MP7/D6 sky130_fd_pr__cap_mim_m3_1 l=2 w=2
X6 vtop MP7/D6 sky130_fd_pr__cap_mim_m3_1 l=2 w=2
X7 vtop MP7/D6 sky130_fd_pr__cap_mim_m3_1 l=2 w=2
X8 vtop MP6/D2 sky130_fd_pr__cap_mim_m3_1 l=2 w=2
X9 vtop MP4/D sky130_fd_pr__cap_mim_m3_1 l=2 w=2
X10 vtop MP7/D6 sky130_fd_pr__cap_mim_m3_1 l=2 w=2
X11 vtop MP6/D2 sky130_fd_pr__cap_mim_m3_1 l=2 w=2
X12 vtop MP7/D6 sky130_fd_pr__cap_mim_m3_1 l=2 w=2
X13 vtop MP6/D2 sky130_fd_pr__cap_mim_m3_1 l=2 w=2
X14 vtop MP6/D2 sky130_fd_pr__cap_mim_m3_1 l=2 w=2
X15 vtop MN5/D sky130_fd_pr__cap_mim_m3_1 l=2 w=2
X16 vtop MN5/D sky130_fd_pr__cap_mim_m3_1 l=2 w=2
X17 vtop MP3/D sky130_fd_pr__cap_mim_m3_1 l=2 w=2
X18 vtop MP7/D6 sky130_fd_pr__cap_mim_m3_1 l=2 w=2
X19 vtop MN5/D sky130_fd_pr__cap_mim_m3_1 l=2 w=2
X20 vtop MP7/D6 sky130_fd_pr__cap_mim_m3_1 l=2 w=2
X21 vtop MP4/D sky130_fd_pr__cap_mim_m3_1 l=2 w=2
X22 vtop MP6/D2 sky130_fd_pr__cap_mim_m3_1 l=2 w=2
X23 vtop MP7/D6 sky130_fd_pr__cap_mim_m3_1 l=2 w=2
X24 vtop MP7/D6 sky130_fd_pr__cap_mim_m3_1 l=2 w=2
X25 vtop MP7/D6 sky130_fd_pr__cap_mim_m3_1 l=2 w=2
X26 vtop MP7/D6 sky130_fd_pr__cap_mim_m3_1 l=2 w=2
X27 vtop MN5/D sky130_fd_pr__cap_mim_m3_1 l=2 w=2
X28 vtop MP7/D6 sky130_fd_pr__cap_mim_m3_1 l=2 w=2
X29 vtop MP7/D6 sky130_fd_pr__cap_mim_m3_1 l=2 w=2
X30 vtop MP7/D6 sky130_fd_pr__cap_mim_m3_1 l=2 w=2
X31 vtop MP6/D2 sky130_fd_pr__cap_mim_m3_1 l=2 w=2
X32 vtop MP7/D6 sky130_fd_pr__cap_mim_m3_1 l=2 w=2
X33 vtop VSS sky130_fd_pr__cap_mim_m3_1 l=2 w=2
X34 vtop MP6/D2 sky130_fd_pr__cap_mim_m3_1 l=2 w=2
X35 vtop MN5/D sky130_fd_pr__cap_mim_m3_1 l=2 w=2
X36 vtop MP7/D6 sky130_fd_pr__cap_mim_m3_1 l=2 w=2
X37 vtop MP7/D6 sky130_fd_pr__cap_mim_m3_1 l=2 w=2
X38 vtop MP7/D6 sky130_fd_pr__cap_mim_m3_1 l=2 w=2
X39 vtop MP7/D6 sky130_fd_pr__cap_mim_m3_1 l=2 w=2
X40 vtop MP3/D sky130_fd_pr__cap_mim_m3_1 l=2 w=2
X41 vtop MN5/D sky130_fd_pr__cap_mim_m3_1 l=2 w=2
X42 vtop MP7/D6 sky130_fd_pr__cap_mim_m3_1 l=2 w=2
X43 vtop MP6/D2 sky130_fd_pr__cap_mim_m3_1 l=2 w=2
X44 vtop MP7/D6 sky130_fd_pr__cap_mim_m3_1 l=2 w=2
X45 vtop MP7/D6 sky130_fd_pr__cap_mim_m3_1 l=2 w=2
X46 vtop MP7/D6 sky130_fd_pr__cap_mim_m3_1 l=2 w=2
X47 vtop MP7/D6 sky130_fd_pr__cap_mim_m3_1 l=2 w=2
X48 vtop MP6/D2 sky130_fd_pr__cap_mim_m3_1 l=2 w=2
X49 vtop MP6/D2 sky130_fd_pr__cap_mim_m3_1 l=2 w=2
X50 vtop MP6/D2 sky130_fd_pr__cap_mim_m3_1 l=2 w=2
X51 vtop MP7/D6 sky130_fd_pr__cap_mim_m3_1 l=2 w=2
X52 vtop MP3/D sky130_fd_pr__cap_mim_m3_1 l=2 w=2
X53 vtop MP6/D2 sky130_fd_pr__cap_mim_m3_1 l=2 w=2
X54 vtop MP7/D6 sky130_fd_pr__cap_mim_m3_1 l=2 w=2
X55 vtop MP7/D6 sky130_fd_pr__cap_mim_m3_1 l=2 w=2
X56 vtop MP7/D6 sky130_fd_pr__cap_mim_m3_1 l=2 w=2
X57 vtop MP7/D6 sky130_fd_pr__cap_mim_m3_1 l=2 w=2
X58 vtop MP6/D2 sky130_fd_pr__cap_mim_m3_1 l=2 w=2
X59 vtop MN5/D sky130_fd_pr__cap_mim_m3_1 l=2 w=2
X60 vtop MP7/D6 sky130_fd_pr__cap_mim_m3_1 l=2 w=2
X61 vtop MP6/D2 sky130_fd_pr__cap_mim_m3_1 l=2 w=2
X62 vtop MP7/D6 sky130_fd_pr__cap_mim_m3_1 l=2 w=2
X63 vtop MP7/D6 sky130_fd_pr__cap_mim_m3_1 l=2 w=2
X64 vtop MP6/D2 sky130_fd_pr__cap_mim_m3_1 l=2 w=2
X65 vtop MP6/D2 sky130_fd_pr__cap_mim_m3_1 l=2 w=2
X66 vtop MP6/D2 sky130_fd_pr__cap_mim_m3_1 l=2 w=2
X67 vtop MN5/D sky130_fd_pr__cap_mim_m3_1 l=2 w=2
X68 vtop MP7/D6 sky130_fd_pr__cap_mim_m3_1 l=2 w=2
X69 vtop MP7/D6 sky130_fd_pr__cap_mim_m3_1 l=2 w=2
X70 vtop MN5/D sky130_fd_pr__cap_mim_m3_1 l=2 w=2
X71 vtop MP7/D6 sky130_fd_pr__cap_mim_m3_1 l=2 w=2
X72 vtop MP4/D sky130_fd_pr__cap_mim_m3_1 l=2 w=2
X73 vtop MP7/D6 sky130_fd_pr__cap_mim_m3_1 l=2 w=2
X74 vtop MP6/D2 sky130_fd_pr__cap_mim_m3_1 l=2 w=2
X75 vtop MP7/D6 sky130_fd_pr__cap_mim_m3_1 l=2 w=2
X76 vtop MP2/D sky130_fd_pr__cap_mim_m3_1 l=2 w=2
X77 vtop MN5/D sky130_fd_pr__cap_mim_m3_1 l=2 w=2
X78 vtop MP6/D2 sky130_fd_pr__cap_mim_m3_1 l=2 w=2
X79 vtop MP7/D6 sky130_fd_pr__cap_mim_m3_1 l=2 w=2
X80 vtop MP7/D6 sky130_fd_pr__cap_mim_m3_1 l=2 w=2
X81 vtop MN5/D sky130_fd_pr__cap_mim_m3_1 l=2 w=2
X82 vtop MN5/D sky130_fd_pr__cap_mim_m3_1 l=2 w=2
X83 vtop MN5/D sky130_fd_pr__cap_mim_m3_1 l=2 w=2
X84 vtop MP4/D sky130_fd_pr__cap_mim_m3_1 l=2 w=2
X85 vtop MP7/D6 sky130_fd_pr__cap_mim_m3_1 l=2 w=2
X86 vtop MP7/D6 sky130_fd_pr__cap_mim_m3_1 l=2 w=2
X87 vtop MP6/D2 sky130_fd_pr__cap_mim_m3_1 l=2 w=2
X88 vtop MP6/D2 sky130_fd_pr__cap_mim_m3_1 l=2 w=2
X89 vtop MP4/D sky130_fd_pr__cap_mim_m3_1 l=2 w=2
X90 vtop MP7/D6 sky130_fd_pr__cap_mim_m3_1 l=2 w=2
X91 vtop MP7/D6 sky130_fd_pr__cap_mim_m3_1 l=2 w=2
X92 vtop MP4/D sky130_fd_pr__cap_mim_m3_1 l=2 w=2
X93 vtop MP7/D6 sky130_fd_pr__cap_mim_m3_1 l=2 w=2
X94 vtop MP7/D6 sky130_fd_pr__cap_mim_m3_1 l=2 w=2
X95 vtop MP7/D6 sky130_fd_pr__cap_mim_m3_1 l=2 w=2
X96 vtop MP3/D sky130_fd_pr__cap_mim_m3_1 l=2 w=2
X97 vtop MP6/D2 sky130_fd_pr__cap_mim_m3_1 l=2 w=2
X98 vtop MP7/D6 sky130_fd_pr__cap_mim_m3_1 l=2 w=2
X99 vtop MP7/D6 sky130_fd_pr__cap_mim_m3_1 l=2 w=2
X100 vtop MP7/D6 sky130_fd_pr__cap_mim_m3_1 l=2 w=2
X101 vtop MP7/D6 sky130_fd_pr__cap_mim_m3_1 l=2 w=2
X102 vtop MP7/D6 sky130_fd_pr__cap_mim_m3_1 l=2 w=2
X103 vtop MP7/D6 sky130_fd_pr__cap_mim_m3_1 l=2 w=2
X104 vtop MP6/D2 sky130_fd_pr__cap_mim_m3_1 l=2 w=2
X105 vtop MP6/D2 sky130_fd_pr__cap_mim_m3_1 l=2 w=2
X106 vtop MN5/D sky130_fd_pr__cap_mim_m3_1 l=2 w=2
X107 vtop MP7/D6 sky130_fd_pr__cap_mim_m3_1 l=2 w=2
X108 vtop MP7/D6 sky130_fd_pr__cap_mim_m3_1 l=2 w=2
X109 vtop MP7/D6 sky130_fd_pr__cap_mim_m3_1 l=2 w=2
X110 vtop MN5/D sky130_fd_pr__cap_mim_m3_1 l=2 w=2
X111 vtop MP7/D6 sky130_fd_pr__cap_mim_m3_1 l=2 w=2
X112 vtop MP7/D6 sky130_fd_pr__cap_mim_m3_1 l=2 w=2
X113 vtop MP7/D6 sky130_fd_pr__cap_mim_m3_1 l=2 w=2
X114 vtop MP6/D2 sky130_fd_pr__cap_mim_m3_1 l=2 w=2
X115 vtop MN5/D sky130_fd_pr__cap_mim_m3_1 l=2 w=2
X116 vtop MN5/D sky130_fd_pr__cap_mim_m3_1 l=2 w=2
X117 vtop MP7/D6 sky130_fd_pr__cap_mim_m3_1 l=2 w=2
X118 vtop MP4/D sky130_fd_pr__cap_mim_m3_1 l=2 w=2
X119 vtop MP6/D2 sky130_fd_pr__cap_mim_m3_1 l=2 w=2
X120 vtop MP7/D6 sky130_fd_pr__cap_mim_m3_1 l=2 w=2
X121 vtop MP7/D6 sky130_fd_pr__cap_mim_m3_1 l=2 w=2
X122 vtop MP7/D6 sky130_fd_pr__cap_mim_m3_1 l=2 w=2
X123 vtop MN5/D sky130_fd_pr__cap_mim_m3_1 l=2 w=2
X124 vtop MP7/D6 sky130_fd_pr__cap_mim_m3_1 l=2 w=2
X125 vtop MP6/D2 sky130_fd_pr__cap_mim_m3_1 l=2 w=2
X126 vtop MP6/D2 sky130_fd_pr__cap_mim_m3_1 l=2 w=2
X127 vtop MP7/D6 sky130_fd_pr__cap_mim_m3_1 l=2 w=2
X128 vtop MP7/D6 sky130_fd_pr__cap_mim_m3_1 l=2 w=2
X129 vtop MP6/D2 sky130_fd_pr__cap_mim_m3_1 l=2 w=2
X130 vtop MP6/D2 sky130_fd_pr__cap_mim_m3_1 l=2 w=2
X131 vtop MP4/D sky130_fd_pr__cap_mim_m3_1 l=2 w=2
X132 vtop MP7/D6 sky130_fd_pr__cap_mim_m3_1 l=2 w=2
X133 vtop MP7/D6 sky130_fd_pr__cap_mim_m3_1 l=2 w=2
X134 vtop MP7/D6 sky130_fd_pr__cap_mim_m3_1 l=2 w=2
X135 vtop MP7/D6 sky130_fd_pr__cap_mim_m3_1 l=2 w=2
X136 vtop MP7/D6 sky130_fd_pr__cap_mim_m3_1 l=2 w=2
X137 vtop MP6/D2 sky130_fd_pr__cap_mim_m3_1 l=2 w=2
X138 vtop MP7/D6 sky130_fd_pr__cap_mim_m3_1 l=2 w=2
X139 vtop MP2/D sky130_fd_pr__cap_mim_m3_1 l=2 w=2
X140 vtop MP6/D2 sky130_fd_pr__cap_mim_m3_1 l=2 w=2
X141 vtop MN5/D sky130_fd_pr__cap_mim_m3_1 l=2 w=2
X142 vtop MN5/D sky130_fd_pr__cap_mim_m3_1 l=2 w=2
X143 vtop MP6/D2 sky130_fd_pr__cap_mim_m3_1 l=2 w=2
X144 vtop MP4/D sky130_fd_pr__cap_mim_m3_1 l=2 w=2
X145 vtop MP7/D6 sky130_fd_pr__cap_mim_m3_1 l=2 w=2
X146 vtop MP2/D sky130_fd_pr__cap_mim_m3_1 l=2 w=2
X147 vtop MP7/D6 sky130_fd_pr__cap_mim_m3_1 l=2 w=2
X148 vtop MP7/D6 sky130_fd_pr__cap_mim_m3_1 l=2 w=2
X149 vtop MP3/D sky130_fd_pr__cap_mim_m3_1 l=2 w=2
X150 vtop MN5/D sky130_fd_pr__cap_mim_m3_1 l=2 w=2
X151 vtop MP6/D2 sky130_fd_pr__cap_mim_m3_1 l=2 w=2
X152 vtop MP7/D6 sky130_fd_pr__cap_mim_m3_1 l=2 w=2
X153 vtop MP7/D6 sky130_fd_pr__cap_mim_m3_1 l=2 w=2
X154 vtop MN5/D sky130_fd_pr__cap_mim_m3_1 l=2 w=2
X155 vtop MP7/D6 sky130_fd_pr__cap_mim_m3_1 l=2 w=2
X156 vtop MP4/D sky130_fd_pr__cap_mim_m3_1 l=2 w=2
X157 vtop MN5/D sky130_fd_pr__cap_mim_m3_1 l=2 w=2
X158 vtop MP6/D2 sky130_fd_pr__cap_mim_m3_1 l=2 w=2
X159 vtop MP7/D6 sky130_fd_pr__cap_mim_m3_1 l=2 w=2
X160 vtop MP7/D6 sky130_fd_pr__cap_mim_m3_1 l=2 w=2
X161 vtop MP4/D sky130_fd_pr__cap_mim_m3_1 l=2 w=2
X162 vtop MP6/D2 sky130_fd_pr__cap_mim_m3_1 l=2 w=2
X163 vtop MP7/D6 sky130_fd_pr__cap_mim_m3_1 l=2 w=2
X164 vtop MP7/D6 sky130_fd_pr__cap_mim_m3_1 l=2 w=2
X165 vtop MP7/D6 sky130_fd_pr__cap_mim_m3_1 l=2 w=2
X166 vtop MP7/D6 sky130_fd_pr__cap_mim_m3_1 l=2 w=2
X167 vtop MP7/D6 sky130_fd_pr__cap_mim_m3_1 l=2 w=2
X168 vtop MP7/D6 sky130_fd_pr__cap_mim_m3_1 l=2 w=2
X169 vtop MN5/D sky130_fd_pr__cap_mim_m3_1 l=2 w=2
X170 vtop MP7/D6 sky130_fd_pr__cap_mim_m3_1 l=2 w=2
X171 vtop MP6/D2 sky130_fd_pr__cap_mim_m3_1 l=2 w=2
X172 vtop MP4/D sky130_fd_pr__cap_mim_m3_1 l=2 w=2
X173 vtop MP7/D6 sky130_fd_pr__cap_mim_m3_1 l=2 w=2
X174 vtop MP6/D2 sky130_fd_pr__cap_mim_m3_1 l=2 w=2
X175 vtop MP7/D6 sky130_fd_pr__cap_mim_m3_1 l=2 w=2
X176 vtop MP7/D6 sky130_fd_pr__cap_mim_m3_1 l=2 w=2
X177 vtop MP7/D6 sky130_fd_pr__cap_mim_m3_1 l=2 w=2
X178 vtop MP6/D2 sky130_fd_pr__cap_mim_m3_1 l=2 w=2
X179 vtop MP6/D2 sky130_fd_pr__cap_mim_m3_1 l=2 w=2
X180 vtop MP7/D6 sky130_fd_pr__cap_mim_m3_1 l=2 w=2
X181 vtop MP4/D sky130_fd_pr__cap_mim_m3_1 l=2 w=2
X182 vtop MP6/D2 sky130_fd_pr__cap_mim_m3_1 l=2 w=2
X183 vtop MP7/D6 sky130_fd_pr__cap_mim_m3_1 l=2 w=2
X184 vtop MP1/D sky130_fd_pr__cap_mim_m3_1 l=2 w=2
X185 vtop MP7/D6 sky130_fd_pr__cap_mim_m3_1 l=2 w=2
X186 vtop MP7/D6 sky130_fd_pr__cap_mim_m3_1 l=2 w=2
X187 vtop MP6/D2 sky130_fd_pr__cap_mim_m3_1 l=2 w=2
X188 vtop MP7/D6 sky130_fd_pr__cap_mim_m3_1 l=2 w=2
X189 vtop MP6/D2 sky130_fd_pr__cap_mim_m3_1 l=2 w=2
X190 vtop MP7/D6 sky130_fd_pr__cap_mim_m3_1 l=2 w=2
X191 vtop MP6/D2 sky130_fd_pr__cap_mim_m3_1 l=2 w=2
X192 vtop MP6/D2 sky130_fd_pr__cap_mim_m3_1 l=2 w=2
X193 vtop MP7/D6 sky130_fd_pr__cap_mim_m3_1 l=2 w=2
X194 vtop MP6/D2 sky130_fd_pr__cap_mim_m3_1 l=2 w=2
X195 vtop MP4/D sky130_fd_pr__cap_mim_m3_1 l=2 w=2
X196 vtop MP7/D6 sky130_fd_pr__cap_mim_m3_1 l=2 w=2
X197 vtop MP6/D2 sky130_fd_pr__cap_mim_m3_1 l=2 w=2
X198 vtop MP7/D6 sky130_fd_pr__cap_mim_m3_1 l=2 w=2
X199 vtop MP3/D sky130_fd_pr__cap_mim_m3_1 l=2 w=2
X200 vtop MP6/D2 sky130_fd_pr__cap_mim_m3_1 l=2 w=2
X201 vtop MP7/D6 sky130_fd_pr__cap_mim_m3_1 l=2 w=2
X202 vtop MP6/D2 sky130_fd_pr__cap_mim_m3_1 l=2 w=2
X203 vtop MN5/D sky130_fd_pr__cap_mim_m3_1 l=2 w=2
X204 vtop MP6/D2 sky130_fd_pr__cap_mim_m3_1 l=2 w=2
X205 vtop MN5/D sky130_fd_pr__cap_mim_m3_1 l=2 w=2
X206 vtop MP7/D6 sky130_fd_pr__cap_mim_m3_1 l=2 w=2
X207 vtop MP2/D sky130_fd_pr__cap_mim_m3_1 l=2 w=2
X208 vtop MP7/D6 sky130_fd_pr__cap_mim_m3_1 l=2 w=2
X209 vtop MP7/D6 sky130_fd_pr__cap_mim_m3_1 l=2 w=2
X210 vtop MP7/D6 sky130_fd_pr__cap_mim_m3_1 l=2 w=2
X211 vtop MP6/D2 sky130_fd_pr__cap_mim_m3_1 l=2 w=2
X212 vtop MN5/D sky130_fd_pr__cap_mim_m3_1 l=2 w=2
X213 vtop MP6/D2 sky130_fd_pr__cap_mim_m3_1 l=2 w=2
X214 vtop MP7/D6 sky130_fd_pr__cap_mim_m3_1 l=2 w=2
X215 vtop MP6/D2 sky130_fd_pr__cap_mim_m3_1 l=2 w=2
X216 vtop MP3/D sky130_fd_pr__cap_mim_m3_1 l=2 w=2
X217 vtop MN5/D sky130_fd_pr__cap_mim_m3_1 l=2 w=2
X218 vtop MP7/D6 sky130_fd_pr__cap_mim_m3_1 l=2 w=2
X219 vtop MP6/D2 sky130_fd_pr__cap_mim_m3_1 l=2 w=2
X220 vtop MP7/D6 sky130_fd_pr__cap_mim_m3_1 l=2 w=2
X221 vtop MN5/D sky130_fd_pr__cap_mim_m3_1 l=2 w=2
X222 vtop MP7/D6 sky130_fd_pr__cap_mim_m3_1 l=2 w=2
X223 vtop MP7/D6 sky130_fd_pr__cap_mim_m3_1 l=2 w=2
X224 vtop MP7/D6 sky130_fd_pr__cap_mim_m3_1 l=2 w=2
X225 vtop MP4/D sky130_fd_pr__cap_mim_m3_1 l=2 w=2
X226 vtop MP6/D2 sky130_fd_pr__cap_mim_m3_1 l=2 w=2
X227 vtop MP7/D6 sky130_fd_pr__cap_mim_m3_1 l=2 w=2
X228 vtop MP0/D sky130_fd_pr__cap_mim_m3_1 l=2 w=2
X229 vtop MP7/D6 sky130_fd_pr__cap_mim_m3_1 l=2 w=2
X230 vtop MP7/D6 sky130_fd_pr__cap_mim_m3_1 l=2 w=2
X231 vtop MP7/D6 sky130_fd_pr__cap_mim_m3_1 l=2 w=2
X232 vtop MP6/D2 sky130_fd_pr__cap_mim_m3_1 l=2 w=2
X233 vtop MP7/D6 sky130_fd_pr__cap_mim_m3_1 l=2 w=2
X234 vtop MP6/D2 sky130_fd_pr__cap_mim_m3_1 l=2 w=2
X235 vtop MP4/D sky130_fd_pr__cap_mim_m3_1 l=2 w=2
X236 vtop MP7/D6 sky130_fd_pr__cap_mim_m3_1 l=2 w=2
X237 vtop MP7/D6 sky130_fd_pr__cap_mim_m3_1 l=2 w=2
X238 vtop MP7/D6 sky130_fd_pr__cap_mim_m3_1 l=2 w=2
X239 vtop MP6/D2 sky130_fd_pr__cap_mim_m3_1 l=2 w=2
X240 vtop MP7/D6 sky130_fd_pr__cap_mim_m3_1 l=2 w=2
X241 vtop MP7/D6 sky130_fd_pr__cap_mim_m3_1 l=2 w=2
X242 vtop MP6/D2 sky130_fd_pr__cap_mim_m3_1 l=2 w=2
X243 vtop MP7/D6 sky130_fd_pr__cap_mim_m3_1 l=2 w=2
X244 vtop MP1/D sky130_fd_pr__cap_mim_m3_1 l=2 w=2
X245 vtop MP6/D2 sky130_fd_pr__cap_mim_m3_1 l=2 w=2
X246 vtop MP7/D6 sky130_fd_pr__cap_mim_m3_1 l=2 w=2
X247 vtop MP7/D6 sky130_fd_pr__cap_mim_m3_1 l=2 w=2
X248 vtop MP7/D6 sky130_fd_pr__cap_mim_m3_1 l=2 w=2
X249 vtop MP6/D2 sky130_fd_pr__cap_mim_m3_1 l=2 w=2
X250 vtop MP6/D2 sky130_fd_pr__cap_mim_m3_1 l=2 w=2
X251 vtop MN5/D sky130_fd_pr__cap_mim_m3_1 l=2 w=2
X252 vtop MP7/D6 sky130_fd_pr__cap_mim_m3_1 l=2 w=2
X253 vtop MP7/D6 sky130_fd_pr__cap_mim_m3_1 l=2 w=2
X254 vtop MP6/D2 sky130_fd_pr__cap_mim_m3_1 l=2 w=2
X255 vtop MP7/D6 sky130_fd_pr__cap_mim_m3_1 l=2 w=2
C0 Vref dn6 0.50499f
C1 MP0/D dn0 0.41364f
C2 dn7 MP6/D2 0.01662f
C3 MP7/D6 dn2 0.01692f
C4 Vref dn4 0.38859f
C5 MP7/D6 vtop 87.7686f
C6 MP4/D MP7/D6 0.0556f
C7 MP7/D6 MP6/D2 2.57196f
C8 dn1 MP1/D 0.39591f
C9 dn7 MP7/D6 0.98876f
C10 dn1 Vref 0.33995f
C11 MN5/D vtop 21.9548f
C12 dn2 MP2/D 0.39848f
C13 dn1 MP0/D 0.05312f
C14 MP4/D dn5 0.04217f
C15 vtop MP3/D 5.5936f
C16 MP4/D MN5/D 3.67405f
C17 MN5/D MP6/D2 1.77738f
C18 vtop MP2/D 2.84833f
C19 MP4/D MP3/D 2.09151f
C20 MP6/D2 MP3/D 0.29544f
C21 dn1 dn0 0.02003f
C22 MP4/D MP2/D 1.02341f
C23 MP6/D2 MP2/D 0.17608f
C24 dn2 MP1/D 0.0542f
C25 Vref dn2 0.33479f
C26 MP1/D vtop 1.15709f
C27 MP4/D MP1/D 0.65887f
C28 MP1/D MP6/D2 0.06284f
C29 MN5/D MP7/D6 0.05973f
C30 MP7/D6 MP3/D 0.0431f
C31 MP4/D Vref 0.18683f
C32 Vref MP6/D2 0.60046f
C33 MP0/D vtop 0.78054f
C34 MP7/D6 MP2/D 0.04731f
C35 dn3 dn2 0.0196f
C36 Vref dn7 0.72805f
C37 MP4/D MP0/D 0.25689f
C38 MP0/D MP6/D2 0.765f
C39 MN5/D dn5 0.51006f
C40 MP7/D6 MP1/D 0.0395f
C41 MN5/D MP3/D 1.25366f
C42 MN5/D MP2/D 1.70481f
C43 Vref MP7/D6 1.07761f
C44 dn6 MP6/D2 0.61676f
C45 MP2/D MP3/D 2.33304f
C46 dn7 dn6 0.01272f
C47 MP4/D dn4 0.52787f
C48 MP0/D MP7/D6 0.06317f
C49 MN5/D MP1/D 1.3075f
C50 dn1 dn2 0.01949f
C51 MP7/D6 dn0 0.01823f
C52 dn3 MP7/D6 0.01692f
C53 MP1/D MP3/D 0.40011f
C54 Vref dn5 0.46481f
C55 MN5/D Vref 0.36963f
C56 MP1/D MP2/D 0.75641f
C57 MP7/D6 dn6 0.0781f
C58 Vref MP3/D 0.12972f
C59 MN5/D MP0/D 0.57961f
C60 Vref MP2/D 0.12638f
C61 MP7/D6 dn4 0.01013f
C62 MP0/D MP3/D 0.13284f
C63 MP0/D MP2/D 0.05396f
C64 dn3 MP3/D 0.39685f
C65 Vref MP1/D 0.12857f
C66 dn6 dn5 0.02861f
C67 MN5/D dn6 0.07413f
C68 dn3 MP2/D 0.05355f
C69 dn5 dn4 0.03344f
C70 MP0/D MP1/D 0.15582f
C71 dn1 MP7/D6 0.01691f
C72 dn4 MP3/D 0.04114f
C73 Vref MP0/D 0.14774f
C74 MP4/D vtop 11.0189f
C75 vtop MP6/D2 43.9862f
C76 Vref dn0 0.21043f
C77 Vref dn3 0.34757f
C78 MP4/D MP6/D2 0.86462f
C79 VDD VSS 0.07989f
C80 dn5 VSS 0.26801f
C81 dn0 VSS 0.47488f
C82 dn1 VSS 0.29273f
C83 dn2 VSS 0.28735f
C84 dn3 VSS 0.29772f
C85 dn4 VSS 0.32146f
C86 MP7/D6 VSS 38.97458f
C87 dn7 VSS 1.24142f
C88 Vref VSS -0.57381f
C89 MP6/D2 VSS 16.35544f
C90 dn6 VSS 0.84104f
C91 MN5/D VSS 37.63082f
C92 MP4/D VSS 5.63123f
C93 MP3/D VSS 4.06072f
C94 MP2/D VSS 2.86201f
C95 MP1/D VSS 3.45233f
C96 MP0/D VSS 3.95734f
.ends

.subckt sky130_fd_pr__nfet_01v8_WLECUA B D0 G0 S1 G1 D2 G2 S3 G3 D4 G4 S5 G5 D6 G6
+ S7 G7 a_4203_n1000#
X0 S7 G6 D6 B sky130_fd_pr__nfet_01v8 ad=1.45 pd=10.29 as=1.45 ps=10.29 w=10 l=5
X1 S5 G4 D4 B sky130_fd_pr__nfet_01v8 ad=1.45 pd=10.29 as=1.45 ps=10.29 w=10 l=5
X2 D2 G1 S1 B sky130_fd_pr__nfet_01v8 ad=1.45 pd=10.29 as=1.45 ps=10.29 w=10 l=5
X3 D4 G3 S3 B sky130_fd_pr__nfet_01v8 ad=1.45 pd=10.29 as=1.45 ps=10.29 w=10 l=5
X4 a_4203_n1000# G7 S7 B sky130_fd_pr__nfet_01v8 ad=2.9 pd=20.58 as=1.45 ps=10.29 w=10 l=5
X5 S1 G0 D0 B sky130_fd_pr__nfet_01v8 ad=1.45 pd=10.29 as=2.9 ps=20.58 w=10 l=5
X6 D6 G5 S5 B sky130_fd_pr__nfet_01v8 ad=1.45 pd=10.29 as=1.45 ps=10.29 w=10 l=5
X7 S3 G2 D2 B sky130_fd_pr__nfet_01v8 ad=1.45 pd=10.29 as=1.45 ps=10.29 w=10 l=5
C0 G1 D2 0.84307f
C1 D6 G6 0.84307f
C2 G0 D0 0.84307f
C3 S5 G4 0.84307f
C4 D4 S5 0.06802f
C5 S1 D0 0.06802f
C6 S3 G2 0.84307f
C7 S1 D2 0.06802f
C8 D6 S5 0.06802f
C9 G1 G0 0.05269f
C10 G3 S3 0.84307f
C11 G1 S1 0.84307f
C12 G5 G4 0.05269f
C13 G7 a_4203_n1000# 0.84307f
C14 G3 G2 0.05269f
C15 S7 a_4203_n1000# 0.06802f
C16 D4 S3 0.06802f
C17 S3 D2 0.06802f
C18 G5 G6 0.05269f
C19 G0 S1 0.84307f
C20 G2 D2 0.84307f
C21 G7 S7 0.84307f
C22 D6 G5 0.84307f
C23 G3 G4 0.05269f
C24 G3 D4 0.84307f
C25 G2 G1 0.05269f
C26 D4 G4 0.84307f
C27 G5 S5 0.84307f
C28 G7 G6 0.05269f
C29 S7 G6 0.84307f
C30 D6 S7 0.06802f
C31 S7 B 2.03595f
C32 D6 B 2.00106f
C33 S5 B 2.00084f
C34 D4 B 2.00084f
C35 S3 B 2.00084f
C36 D2 B 2.00106f
C37 S1 B 2.03595f
C38 D0 B 1.80064f
C39 a_4203_n1000# B 1.80064f
.ends

.subckt decap Vref VSS
XMC0 VSS VSS Vref VSS Vref VSS Vref VSS Vref VSS Vref VSS Vref VSS Vref VSS Vref VSS
+ sky130_fd_pr__nfet_01v8_WLECUA
XMC1 VSS VSS Vref VSS Vref VSS Vref VSS Vref VSS Vref VSS Vref VSS Vref VSS Vref VSS
+ sky130_fd_pr__nfet_01v8_WLECUA
XMC2 VSS VSS Vref VSS Vref VSS Vref VSS Vref VSS Vref VSS Vref VSS Vref VSS Vref VSS
+ sky130_fd_pr__nfet_01v8_WLECUA
C0 Vref VSS 6.7344f
.ends

.subckt sky130_fd_pr__res_xhigh_po_1p41_BDUJGV B R1 R2
X0 R1 R2 B sky130_fd_pr__res_xhigh_po_1p41 l=36
C0 R2 B 0.66301f
C1 R1 B 0.66301f
.ends

.subckt sky130_fd_pr__cap_mim_m3_1_CGC2GW C2 C1 VSUBS
X0 C1 C2 sky130_fd_pr__cap_mim_m3_1 l=22 w=22
X1 C1 C2 sky130_fd_pr__cap_mim_m3_1 l=22 w=22
C0 C2 C1 85.55979f
C1 C2 VSUBS 25.05906f
.ends

.subckt vcm_gen vcm Vref VSS
XR1 VSS Vref vcm sky130_fd_pr__res_xhigh_po_1p41_BDUJGV
XR2 VSS VSS vcm sky130_fd_pr__res_xhigh_po_1p41_BDUJGV
XCcm VSS vcm VSS sky130_fd_pr__cap_mim_m3_1_CGC2GW
C0 vcm VSS 1.60505f
C1 Vref VSS 0.03349f
.ends

.subckt sky130_fd_pr__nfet_01v8_87U5T8 B D S G
X0 S G D B sky130_fd_pr__nfet_01v8 ad=0.58 pd=4.58 as=0.58 ps=4.58 w=2 l=0.6
C0 G S 0.08174f
C1 D G 0.08174f
C2 D S 0.08687f
C3 S B 0.37266f
C4 D B 0.37266f
.ends

.subckt sky130_fd_pr__nfet_01v8_F2GPUV B D S G
X0 S G D B sky130_fd_pr__nfet_01v8 ad=0.29 pd=2.58 as=0.29 ps=2.58 w=1 l=0.15
C0 G S 0.02676f
C1 D G 0.02676f
C2 D S 0.08701f
C3 S B 0.25019f
C4 D B 0.25019f
.ends

.subckt sky130_fd_pr__pfet_01v8_GJK8GW B D0 G0 S1 G1 D2 G2 S3 G3 a_287_n200# VSUBS
X0 S1 G0 D0 B sky130_fd_pr__pfet_01v8 ad=0.29 pd=2.29 as=0.58 ps=4.58 w=2 l=0.5
X1 a_287_n200# G3 S3 B sky130_fd_pr__pfet_01v8 ad=0.58 pd=4.58 as=0.29 ps=2.29 w=2 l=0.5
X2 S3 G2 D2 B sky130_fd_pr__pfet_01v8 ad=0.29 pd=2.29 as=0.29 ps=2.29 w=2 l=0.5
X3 D2 G1 S1 B sky130_fd_pr__pfet_01v8 ad=0.29 pd=2.29 as=0.29 ps=2.29 w=2 l=0.5
C0 S1 G0 0.07207f
C1 B D0 0.1377f
C2 B G2 0.20358f
C3 G2 G1 0.05517f
C4 G2 S3 0.07207f
C5 S1 D0 0.09782f
C6 B G1 0.20358f
C7 G2 D2 0.07207f
C8 B S3 0.06308f
C9 G0 D0 0.07207f
C10 B D2 0.06308f
C11 G1 D2 0.07207f
C12 B a_287_n200# 0.1377f
C13 G3 G2 0.05517f
C14 D2 S3 0.09782f
C15 B S1 0.06308f
C16 S1 G1 0.07207f
C17 a_287_n200# S3 0.09782f
C18 B G3 0.24048f
C19 B G0 0.24048f
C20 G3 S3 0.07207f
C21 G1 G0 0.05517f
C22 S1 D2 0.09782f
C23 a_287_n200# G3 0.07207f
C24 S3 VSUBS 0.05935f
C25 D2 VSUBS 0.0452f
C26 S1 VSUBS 0.05935f
C27 D0 VSUBS 0.09598f
C28 B VSUBS 3.00136f
C29 a_287_n200# VSUBS 0.09598f
.ends

.subckt sky130_fd_pr__nfet_01v8_6ZC5G7 B D S G
X0 S G D B sky130_fd_pr__nfet_01v8 ad=0.29 pd=2.58 as=0.29 ps=2.58 w=1 l=0.15
C0 D S 0.08701f
C1 G S 0.02676f
C2 G D 0.02676f
C3 S B 0.25019f
C4 D B 0.25019f
.ends

.subckt sky130_fd_pr__pfet_01v8_5YQU8J B D S G VSUBS
X0 S G D B sky130_fd_pr__pfet_01v8 ad=0.58 pd=4.58 as=0.58 ps=4.58 w=2 l=0.15
C0 S D 0.17277f
C1 S G 0.04023f
C2 S B 0.12129f
C3 G D 0.04023f
C4 B D 0.12129f
C5 B G 0.23095f
C6 S VSUBS 0.10779f
C7 D VSUBS 0.10779f
C8 B VSUBS 1.46341f
.ends

.subckt sky130_fd_pr__pfet_01v8_53SGHS B D S G VSUBS
X0 S G D B sky130_fd_pr__pfet_01v8 ad=0.58 pd=4.58 as=0.58 ps=4.58 w=2 l=0.15
C0 S D 0.17277f
C1 S G 0.04023f
C2 S B 0.12129f
C3 G D 0.04023f
C4 B D 0.12129f
C5 B G 0.23095f
C6 S VSUBS 0.10779f
C7 D VSUBS 0.10779f
C8 B VSUBS 1.46341f
.ends

.subckt sky130_fd_pr__pfet_01v8_WXVH9J B D S G VSUBS
X0 S G D B sky130_fd_pr__pfet_01v8 ad=1.16 pd=8.58 as=1.16 ps=8.58 w=4 l=0.15
C0 S D 0.3443f
C1 S G 0.06695f
C2 S B 0.22659f
C3 G D 0.06695f
C4 B D 0.22659f
C5 B G 0.23379f
C6 S VSUBS 0.1603f
C7 D VSUBS 0.1603f
C8 B VSUBS 2.11349f
.ends

.subckt comparator inp inn clk outp outn MB3/G S4/D MA3/G S4/G VDD VSS M7/D
XS1 VSS S1/D VSS S4/G sky130_fd_pr__nfet_01v8_87U5T8
XS2 VSS S2/D VSS S4/G sky130_fd_pr__nfet_01v8_87U5T8
XS3 VSS S3/D VSS S4/G sky130_fd_pr__nfet_01v8_87U5T8
XS4 VSS S4/D VSS S4/G sky130_fd_pr__nfet_01v8_87U5T8
XMI2N VSS MB3/G VSS S3/D sky130_fd_pr__nfet_01v8_F2GPUV
XM1 M7/D S1/D inp M7/D inp S1/D inp M7/D inp S1/D VSS sky130_fd_pr__pfet_01v8_GJK8GW
XMI1N VSS MA3/G VSS S4/D sky130_fd_pr__nfet_01v8_6ZC5G7
XMIN VSS S4/G VSS clk sky130_fd_pr__nfet_01v8_34VMYE
XM2 M7/D S2/D inn M7/D inn S2/D inn M7/D inn S2/D VSS sky130_fd_pr__pfet_01v8_GJK8GW
XMI1P VDD MA3/G VDD S4/D VSS sky130_fd_pr__pfet_01v8_5YQU8J
XMI2P VDD MB3/G VDD S3/D VSS sky130_fd_pr__pfet_01v8_53SGHS
XM4 VDD S4/D S2/D S3/D VSS sky130_fd_pr__pfet_01v8_VJT448
XM3 VDD S3/D S1/D S4/D VSS sky130_fd_pr__pfet_01v8_VJT448
XMIP VDD S4/G VDD clk VSS sky130_fd_pr__pfet_01v8_VJT448
XM5 VSS S3/D VSS S4/D sky130_fd_pr__nfet_01v8_34VMYE
XM6 VSS S4/D VSS S3/D sky130_fd_pr__nfet_01v8_34VMYE
XM7 VDD M7/D VDD S4/G VSS sky130_fd_pr__pfet_01v8_WXVH9J
XMB2 VDD outn VDD outp VSS sky130_fd_pr__pfet_01v8_7HN6Y2
XMB1 VDD outn VDD MB3/G VSS sky130_fd_pr__pfet_01v8_7HN6Y2
XMA1 VDD outp VDD MA3/G VSS sky130_fd_pr__pfet_01v8_7HN6Y2
XMB3 VSS outn MB4/D MB3/G sky130_fd_pr__nfet_01v8_NK2ZG9
XMA2 VDD outp VDD outn VSS sky130_fd_pr__pfet_01v8_7HN6Y2
XMA3 VSS outp MA4/D MA3/G sky130_fd_pr__nfet_01v8_NK2ZG9
XMB4 VSS MB4/D VSS outp sky130_fd_pr__nfet_01v8_NK2ZG9
XMA4 VSS MA4/D VSS outn sky130_fd_pr__nfet_01v8_NK2ZG9
C0 S4/D M7/D 0.03993f
C1 MB4/D MB3/G 0.02119f
C2 VDD S2/D 0.5264f
C3 MB4/D outn 0.11992f
C4 S3/D outp 0.12342f
C5 outn MB3/G 0.24626f
C6 inn M7/D 0.16657f
C7 clk S1/D 0.07037f
C8 S3/D VDD 0.48735f
C9 S4/D S4/G 0.6753f
C10 MA4/D outp 0.04597f
C11 S3/D MA3/G 0.01873f
C12 VDD S1/D 0.32194f
C13 MA4/D MA3/G 0.26498f
C14 S2/D MB3/G 0.04781f
C15 VDD M7/D 0.69771f
C16 clk S4/G 0.34475f
C17 inn inp 0.01243f
C18 S3/D MB3/G 0.65303f
C19 VDD S4/G 0.62515f
C20 VDD inp 0.05141f
C21 S3/D S2/D 0.10932f
C22 S4/D outp 0.25666f
C23 S2/D S1/D 0.05161f
C24 M7/D S2/D 0.48736f
C25 S4/D VDD 0.75506f
C26 S3/D S1/D 0.24377f
C27 S4/D MA3/G 0.82168f
C28 inn VDD 0.1829f
C29 S2/D S4/G 0.17409f
C30 VDD clk 0.35949f
C31 M7/D S1/D 0.42559f
C32 MB4/D S4/D 0.07938f
C33 S4/D MB3/G 0.15634f
C34 S3/D S4/G 0.45578f
C35 VDD outp 0.55706f
C36 S4/D outn 0.06664f
C37 outp MA3/G 0.18297f
C38 S4/G S1/D 0.38004f
C39 VDD MA3/G 1.08574f
C40 M7/D S4/G 0.56637f
C41 inp S1/D 0.17491f
C42 MB4/D outp 0.02306f
C43 S4/D S2/D 0.16122f
C44 outp MB3/G 0.44333f
C45 M7/D inp 0.17391f
C46 outn outp 0.32505f
C47 VDD MB3/G 0.87835f
C48 S4/D S3/D 0.95325f
C49 inn S2/D 0.15553f
C50 MB4/D MA3/G 0.13289f
C51 VDD outn 0.68169f
C52 MA3/G MB3/G 0.13325f
C53 MA4/D S4/D 0.03863f
C54 outn MA3/G 0.13259f
C55 S4/G inp 0.06238f
C56 S4/D S1/D 0.10241f
C57 clk VSS 0.19819f
C58 outn VSS 0.10941f
C59 S4/D VSS 1.13633f
C60 MA4/D VSS 0.06458f
C61 MB4/D VSS 0.24804f
C62 outp VSS 0.06057f
C63 MA3/G VSS 0.95602f
C64 VDD VSS -0.43421f
C65 S3/D VSS 1.16086f
C66 S2/D VSS 0.58021f
C67 inn VSS -0.0295f
C68 S4/G VSS 1.44195f
C69 M7/D VSS -0.91245f
C70 inp VSS -0.03034f
C71 MB3/G VSS 0.4016f
C72 S1/D VSS 0.55544f
.ends

.subckt adc_core phi clk vin comp dn7 VDD dn6 dn5 VSS dn4 dn3 dn2 dn1 Vref dn0
Xbootstrap_switch_0 phi vin cdac_0/vtop bootstrap_switch_0/M9/G bootstrap_switch_0/M9/D
+ bootstrap_switch_0/MIP/D bootstrap_switch_0/M8/G bootstrap_switch_0/M8/S VDD VSS
+ bootstrap_switch
Xdecap2_0 decap2_0/vcm VSS Vref VSS decap2
Xcdac_0 dn2 dn5 dn6 dn7 cdac_0/vtop VDD dn4 cdac_0/MP7/D6
+ cdac_0/MN5/D dn1 dn3 cdac_0/MP6/D2 Vref dn0 VSS cdac
Xdecap_0 Vref VSS decap
Xvcm_gen_0 decap2_0/vcm Vref VSS vcm_gen
Xcomparator_0 cdac_0/vtop decap2_0/vcm clk comp comparator_0/outn comparator_0/MB3/G
+ comparator_0/S4/D comparator_0/MA3/G comparator_0/S4/G VDD VSS comparator_0/M7/D
+ comparator
C0 VDD cdac_0/MP7/D6 0.21122f
C1 uio_in[3] uio_in[4] 0.01551f
C2 cdac_0/vtop VDD 2.54114f
C3 Vref cdac_0/MP6/D2 0.07673f
C4 uo_out[0] rst_n 0.02634f
C5 comp Vref 0.05707f
C6 uo_out[1] uo_out[4] 0.10491f
C7 ui_in[5] ui_in[6] 0.01551f
C8 phi bootstrap_switch_0/M9/G 0.01142f
C9 uo_out[2] uo_out[4] 0.05594f
C10 dn3 dn2 0.08755f
C11 uo_out[6] uo_out[4] 0.49934f
C12 uio_in[0] ui_in[7] 0.01551f
C13 decap2_0/vcm VDD 0.28811f
C14 uo_out[0] uo_out[4] 0.43462f
C15 uo_out[6] uio_out[0] 0.12684f
C16 comp dn7 0.01216f
C17 rst_n ui_in[0] 0.0205f
C18 uo_out[1] uo_out[2] 0.17656f
C19 uo_out[1] uo_out[6] 0.10046f
C20 ui_in[1] ui_in[0] 0.01551f
C21 decap2_0/vcm cdac_0/vtop 0.25385f
C22 uo_out[0] uo_out[1] 0.26901f
C23 dn3 dn4 0.10807f
C24 rst_n clk 0.16605f
C25 comparator_0/S4/G Vref 0.04814f
C26 uo_out[2] uo_out[6] 0.15632f
C27 comparator_0/MB3/G comp 0.05193f
C28 uo_out[0] uo_out[2] 1.05758f
C29 uio_in[2] uio_in[1] 0.01551f
C30 Vref dn5 0.0305f
C31 Vref dn7 0.06834f
C32 dn1 dn0 0.01125f
C33 VDD comparator_0/S4/D 0.02298f
C34 clk uo_out[4] 0.0902f
C35 uo_out[7] uo_out[4] 0.10998f
C36 vin cdac_0/vtop 0.01463f
C37 clk uio_out[0] 0.07761f
C38 dn2 Vref 0.02661f
C39 comparator_0/MA3/G VDD 0.01712f
C40 uo_out[7] uio_out[0] 0.41649f
C41 bootstrap_switch_0/M9/G cdac_0/vtop 0.02901f
C42 uo_out[1] clk 0.86267f
C43 comp VDD 0.39125f
C44 uo_out[3] uo_out[4] 0.98134f
C45 uo_out[5] uo_out[4] 0.18088f
C46 clk uo_out[2] 0.05433f
C47 clk Vref 0.51586f
C48 clk uo_out[6] 0.11045f
C49 comparator_0/MA3/G cdac_0/MP7/D6 0.0169f
C50 uo_out[5] uio_out[0] 0.04221f
C51 clk comparator_0/M7/D 0.01611f
C52 uo_out[0] clk 0.11845f
C53 uo_out[7] uo_out[6] 0.54937f
C54 uio_in[0] uio_in[1] 0.01551f
C55 bootstrap_switch_0/MIP/D Vref 0.07534f
C56 uo_out[1] uo_out[3] 0.93265f
C57 Vref dn4 0.02221f
C58 comp cdac_0/vtop 0.06349f
C59 uo_out[5] uo_out[1] 0.12225f
C60 Vref bootstrap_switch_0/M8/S 0.069f
C61 uo_out[3] uo_out[2] 0.07307f
C62 uio_in[6] uio_in[7] 0.01551f
C63 uo_out[5] uo_out[2] 0.52873f
C64 uo_out[3] uo_out[6] 0.10306f
C65 Vref bootstrap_switch_0/M9/D 0.02121f
C66 uo_out[5] uo_out[6] 0.13097f
C67 VDD Vref 6.13186f
C68 ui_in[3] ui_in[4] 0.01551f
C69 uo_out[0] uo_out[3] 0.14217f
C70 uo_out[5] uo_out[0] 0.12146f
C71 uio_in[3] uio_in[2] 0.01551f
C72 dn4 dn5 0.08035f
C73 dn6 Vref 0.03496f
C74 cdac_0/MN5/D Vref 0.08523f
C75 Vref cdac_0/MP7/D6 0.08035f
C76 clk ena 0.01632f
C77 cdac_0/vtop Vref 0.1342f
C78 VDD sar_logic_0/w_514_527# 0.84651f
C79 phi bootstrap_switch_0/M8/S 0.04784f
C80 comparator_0/S4/G cdac_0/vtop 0.15234f
C81 VDD dn7 0.17386f
C82 bootstrap_switch_0/M8/G phi 0.25191f
C83 clk comparator_0/S1/D 0.01879f
C84 clk uo_out[7] 0.0802f
C85 dn6 dn5 0.23758f
C86 comparator_0/M7/D cdac_0/vtop 0.04219f
C87 dn0 Vref 0.04088f
C88 phi bootstrap_switch_0/M9/D 1.35823f
C89 dn6 dn7 0.0198f
C90 phi VDD 0.04589f
C91 ui_in[3] ui_in[2] 0.01551f
C92 decap2_0/vcm Vref 2.55664f
C93 ui_in[6] ui_in[7] 0.01551f
C94 clk uo_out[3] 0.15048f
C95 uo_out[5] clk 0.05426f
C96 uo_out[3] uo_out[7] 0.06405f
C97 decap2_0/vcm comparator_0/M7/D 0.02678f
C98 uio_in[4] uio_in[5] 0.01551f
C99 clk VDD 0.14333f
C100 phi cdac_0/MP7/D6 0.08812f
C101 uo_out[5] uo_out[7] 0.26192f
C102 phi cdac_0/vtop 0.2839f
C103 dn1 Vref 0.02489f
C104 bootstrap_switch_0/M8/G bootstrap_switch_0/M8/S -0.02062f
C105 phi dn0 0.01033f
C106 bootstrap_switch_0/MIP/D VDD 0.14048f
C107 comp comparator_0/MA3/G 0.06978f
C108 uo_out[5] uo_out[3] 0.12194f
C109 clk cdac_0/vtop 0.04223f
C110 bootstrap_switch_0/M8/G VDD -0.01657f
C111 uio_in[6] uio_in[5] 0.01551f
C112 ui_in[4] ui_in[5] 0.01551f
C113 dn3 Vref 0.04897f
C114 ui_in[2] ui_in[1] 0.01551f
C115 dn6 VDD 0.24255f
C116 cdac_0/vtop bootstrap_switch_0/M8/S 0.0381f
C117 uo_out[0] uio_in[7] 0.01668f
C118 decap2_0/vcm clk 0.11306f
C119 dn2 dn1 0.1132f
C120 cdac_0/vtop bootstrap_switch_0/M9/D 0.31696f
C121 ua[2] VSS 0.14709f
C122 ua[3] VSS 0.14709f
C123 ua[4] VSS 0.14696f
C124 ua[5] VSS 0.14696f
C125 ua[6] VSS 0.14696f
C126 ua[7] VSS 0.14696f
C127 ena VSS 0.06988f
C128 ui_in[0] VSS 0.04185f
C129 ui_in[1] VSS 0.04236f
C130 ui_in[2] VSS 0.0427f
C131 ui_in[3] VSS 0.0427f
C132 ui_in[4] VSS 0.04219f
C133 ui_in[5] VSS 0.0424f
C134 ui_in[6] VSS 0.04232f
C135 ui_in[7] VSS 0.04219f
C136 uio_in[0] VSS 0.04219f
C137 uio_in[1] VSS 0.04186f
C138 uio_in[2] VSS 0.04186f
C139 uio_in[3] VSS 0.04162f
C140 uio_in[4] VSS 0.04162f
C141 uio_in[5] VSS 0.04135f
C142 uio_in[6] VSS 0.04135f
C143 uio_in[7] VSS 0.04049f
C144 clk VSS 3.62518f
C145 comparator_0/outn VSS -0.64244f
C146 comparator_0/S4/D VSS -0.94608f
C147 comparator_0/MA4/D VSS -0.20677f
C148 comparator_0/MB4/D VSS -0.2086f
C149 comp VSS 1.96945f
C150 comparator_0/MA3/G VSS -0.58626f
C151 VDD VSS 20.53516f
C152 comparator_0/S3/D VSS -0.93601f
C153 comparator_0/S2/D VSS -0.58538f
C154 comparator_0/S4/G VSS -0.98275f
C155 comparator_0/M7/D VSS -1.71856f
C156 cdac_0/vtop VSS 2.20766f
C157 comparator_0/MB3/G VSS -0.58995f
C158 comparator_0/S1/D VSS -0.625f
C159 decap2_0/vcm VSS 2.4631f
C160 rst_n VSS 1.11353f
C161 uo_out[0] VSS 1.05978f
C162 uo_out[1] VSS 0.33606f
C163 uo_out[2] VSS 0.84949f
C164 uo_out[3] VSS 0.32164f
C165 uo_out[4] VSS 0.36492f
C166 uo_out[5] VSS 1.01208f
C167 uo_out[6] VSS 0.48843f
C168 uo_out[7] VSS 0.62577f
C169 uio_out[0] VSS 1.01276f
C170 sar_logic_0/w_514_527# VSS 0.84651f ; **FLOATING
C171 dn5 VSS 0.91388f
C172 dn0 VSS 1.76966f
C173 dn1 VSS 1.18497f
C174 dn2 VSS 0.61165f
C175 dn3 VSS 0.65256f
C176 dn4 VSS 0.76961f
C177 cdac_0/MP7/D6 VSS -2.80116f
C178 dn7 VSS 0.58977f
C179 cdac_0/MP6/D2 VSS -1.43688f
C180 dn6 VSS 1.15539f
C181 cdac_0/MN5/D VSS -0.4323f
C182 cdac_0/MP4/D VSS -0.25287f
C183 cdac_0/MP3/D VSS -0.12906f
C184 cdac_0/MP2/D VSS -0.12793f
C185 cdac_0/MP1/D VSS -0.12955f
C186 cdac_0/MP0/D VSS -0.12208f
C187 Vref VSS -64.0569f
C188 vin VSS 0.69999f
C189 bootstrap_switch_0/M8/S VSS -1.8174f
C190 bootstrap_switch_0/MIP/D VSS -0.19926f
C191 phi VSS 1.4888f
C192 bootstrap_switch_0/M8/G VSS -0.39672f
C193 bootstrap_switch_0/M9/D VSS -1.44712f
C194 bootstrap_switch_0/M14/S VSS -0.15663f
C195 bootstrap_switch_0/M9/G VSS -0.58755f
Rtie0 bootstrap_switch_0/M14/S VSS 1G
Rtie1 bootstrap_switch_0/M9/D VSS 1G
Rtie2 cdac_0/MP0/D VSS 1G
Rtie3 cdac_0/MP1/D VSS 1G
Rtie4 cdac_0/MP2/D VSS 1G
Rtie5 cdac_0/MP3/D VSS 1G
Rtie6 cdac_0/MP4/D VSS 1G
Rtie7 cdac_0/MP7/D6 VSS 1G
Rtie8 comparator_0/MA4/D VSS 1G
Rtie9 comparator_0/MB3/G VSS 1G
Rtie10 comparator_0/MB4/D VSS 1G
Rtie11 comparator_0/S1/D VSS 1G
Rtie12 comparator_0/S2/D VSS 1G
Rtie13 comparator_0/S3/D VSS 1G
Rtie14 ena VSS 1G
Rtie15 rst_n VSS 1G
Rtie16 sar_logic_0/w_514_527# VSS 1G
Rtie17 ua[2] VSS 1G
Rtie18 ua[3] VSS 1G
Rtie19 ua[4] VSS 1G
Rtie20 ua[5] VSS 1G
Rtie21 ua[6] VSS 1G
Rtie22 ua[7] VSS 1G
Rtie23 ui_in[0] VSS 1G
Rtie24 ui_in[1] VSS 1G
Rtie25 ui_in[2] VSS 1G
Rtie26 ui_in[3] VSS 1G
Rtie27 ui_in[4] VSS 1G
Rtie28 ui_in[5] VSS 1G
Rtie29 ui_in[6] VSS 1G
Rtie30 ui_in[7] VSS 1G
Rtie31 uio_in[0] VSS 1G
Rtie32 uio_in[1] VSS 1G
Rtie33 uio_in[2] VSS 1G
Rtie34 uio_in[3] VSS 1G
Rtie35 uio_in[4] VSS 1G
Rtie36 uio_in[5] VSS 1G
Rtie37 uio_in[6] VSS 1G
Rtie38 uio_in[7] VSS 1G
Rtie39 uio_out[0] VSS 1G
Rtie40 uo_out[0] VSS 1G
Rtie41 uo_out[1] VSS 1G
Rtie42 uo_out[2] VSS 1G
Rtie43 uo_out[3] VSS 1G
Rtie44 uo_out[4] VSS 1G
Rtie45 uo_out[5] VSS 1G
Rtie46 uo_out[6] VSS 1G
Rtie47 uo_out[7] VSS 1G
.ends
