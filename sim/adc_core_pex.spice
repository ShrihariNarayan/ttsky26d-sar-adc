* adc_core_pex.spice -- post-layout (C-only PEX, Magic) netlist of the full tile analog core,
* generated from tt_um_shriharinarayan_sar_adc by mk_core.py. Pin order = xschem adc_core.
* NGSPICE file created from tt_um_shriharinarayan_sar_adc.ext - technology: sky130A

.subckt sky130_fd_pr__nfet_01v8_34VMYE B D S G
X0 S G D B sky130_fd_pr__nfet_01v8 ad=0.29 pd=2.58 as=0.29 ps=2.58 w=1 l=0.15
C0 D S 0.08701f
C1 G D 0.02676f
C2 G S 0.02676f
C3 S B 0.25019f
C4 D B 0.25019f
.ends

.subckt sky130_fd_pr__nfet_01v8_JSF6K7 B D S G
X0 S G D B sky130_fd_pr__nfet_01v8 ad=1.16 pd=8.58 as=1.16 ps=8.58 w=4 l=0.15
C0 D S 0.3443f
C1 G D 0.06815f
C2 G S 0.06815f
C3 S B 0.47525f
C4 D B 0.47525f
.ends

.subckt sky130_fd_pr__pfet_01v8_7HN6Y2 B D S G VSUBS
X0 S G D B sky130_fd_pr__pfet_01v8 ad=0.29 pd=2.58 as=0.29 ps=2.58 w=1 l=0.15
C0 G D 0.02568f
C1 B S 0.06826f
C2 B G 0.22722f
C3 G S 0.02568f
C4 B D 0.06826f
C5 D S 0.08701f
C6 S VSUBS 0.08163f
C7 D VSUBS 0.08163f
C8 B VSUBS 1.13906f
.ends

.subckt sky130_fd_pr__pfet_01v8_VJT448 B D S G VSUBS
X0 S G D B sky130_fd_pr__pfet_01v8 ad=0.58 pd=4.58 as=0.58 ps=4.58 w=2 l=0.15
C0 G D 0.04023f
C1 B S 0.12129f
C2 B G 0.23095f
C3 G S 0.04023f
C4 B D 0.12129f
C5 D S 0.17277f
C6 S VSUBS 0.10779f
C7 D VSUBS 0.10779f
C8 B VSUBS 1.46341f
.ends

.subckt sky130_fd_pr__nfet_01v8_NK2ZG9 B D S G
X0 S G D B sky130_fd_pr__nfet_01v8 ad=0.58 pd=4.58 as=0.58 ps=4.58 w=2 l=0.15
C0 D S 0.17277f
C1 G D 0.0414f
C2 G S 0.0414f
C3 S B 0.32587f
C4 D B 0.32587f
.ends

.subckt sky130_fd_pr__cap_mim_m3_1_QUBC75 C2 C1 VSUBS
X0 C1 C2 sky130_fd_pr__cap_mim_m3_1 l=11 w=11
X1 C1 C2 sky130_fd_pr__cap_mim_m3_1 l=11 w=11
C0 C2 C1 22.5661f
C1 C2 VSUBS 9.82634f
.ends

.subckt bootstrap_switch phi vin vout M9/G M9/D MIP/D M8/G M8/S VDD VSS
XM10 VSS M14/S VSS MIP/D sky130_fd_pr__nfet_01v8_34VMYE
XM11 VSS vin vout M9/G sky130_fd_pr__nfet_01v8_34VMYE
XM12 VSS VSS M9/D MIP/D sky130_fd_pr__nfet_01v8_34VMYE
XM14 VSS M9/G M14/S VDD sky130_fd_pr__nfet_01v8_JSF6K7
XM15 VSS M8/G M9/D phi sky130_fd_pr__nfet_01v8_34VMYE
XM16 VDD M8/G VDD phi VSS sky130_fd_pr__pfet_01v8_7HN6Y2
XMIN VSS MIP/D VSS phi sky130_fd_pr__nfet_01v8_34VMYE
XM3 M8/S M8/S VDD M9/G VSS sky130_fd_pr__pfet_01v8_VJT448
XMIP VDD MIP/D VDD phi VSS sky130_fd_pr__pfet_01v8_VJT448
XM8 M8/S M9/G M8/S M8/G VSS sky130_fd_pr__pfet_01v8_VJT448
XM9 VSS M9/D vin M9/G sky130_fd_pr__nfet_01v8_NK2ZG9
XC2 M9/D M8/S VSS sky130_fd_pr__cap_mim_m3_1_QUBC75
C0 M8/G M8/S 0.34008f
C1 VDD M9/G 0.4759f
C2 VDD phi 0.45297f
C3 M9/G M8/S 0.45599f
C4 phi M8/S 0.13512f
C5 VDD MIP/D 0.23362f
C6 M14/S M9/G 0.09618f
C7 M14/S phi 0.02116f
C8 M9/G M8/G 0.31053f
C9 VDD M9/D 0.02585f
C10 phi M8/G 0.20328f
C11 M14/S MIP/D 0.41663f
C12 M9/D M8/S 0.30946f
C13 vin M9/G 0.08072f
C14 phi M9/G 0.62528f
C15 M9/D M8/G 0.29653f
C16 VDD M8/S 0.31139f
C17 MIP/D M9/G 0.01865f
C18 MIP/D phi 0.15759f
C19 vin vout 0.02333f
C20 VDD M14/S 0.03539f
C21 vin M9/D 0.05376f
C22 M9/G M9/D 0.08006f
C23 phi M9/D 0.13792f
C24 VDD M8/G 0.2697f
C25 VDD VSS 0.4137f
C26 vin VSS 0.69586f
C27 M8/S VSS 0.39355f
C28 MIP/D VSS 2.42943f
C29 phi VSS 1.62164f
C30 M8/G VSS 1.14838f
C31 M9/D VSS 1.90668f
C32 M14/S VSS 0.71207f
C33 M9/G VSS 1.83168f
C34 vout VSS 0.05157f
.ends

.subckt sky130_fd_pr__pfet_01v8_lvt_TEQ27F B D S G VSUBS
X0 S G D B sky130_fd_pr__pfet_01v8_lvt ad=0.29 pd=2.58 as=0.29 ps=2.58 w=1 l=0.35
C0 S G 0.02786f
C1 B D 0.0758f
C2 B S 0.0758f
C3 B G 0.2243f
C4 S D 0.06058f
C5 G D 0.02786f
C6 S VSUBS 0.08159f
C7 D VSUBS 0.08159f
C8 B VSUBS 1.22649f
.ends

.subckt sky130_fd_pr__nfet_01v8_PHAC7Z B D S G
X0 S G D B sky130_fd_pr__nfet_01v8 ad=0.145 pd=1.58 as=0.145 ps=1.58 w=0.5 l=0.15
C0 G S 0.0184f
C1 G D 0.0184f
C2 D S 0.04413f
C3 S B 0.21137f
C4 D B 0.21137f
.ends

.subckt sky130_fd_pr__pfet_01v8_lvt_DQLGWQ B D S G VSUBS
X0 S G D B sky130_fd_pr__pfet_01v8_lvt ad=1.16 pd=8.58 as=1.16 ps=8.58 w=4 l=0.35
C0 S G 0.10872f
C1 B D 0.246f
C2 B S 0.246f
C3 B G 0.22873f
C4 S D 0.23983f
C5 G D 0.10872f
C6 S VSUBS 0.15438f
C7 D VSUBS 0.15438f
C8 B VSUBS 2.27054f
.ends

.subckt sky130_fd_pr__pfet_01v8_lvt_EXY38E B D0 G0 S1 G1 a_99_n400# VSUBS
X0 a_99_n400# G1 S1 B sky130_fd_pr__pfet_01v8_lvt ad=1.16 pd=8.58 as=0.58 ps=4.29 w=4 l=0.35
X1 S1 G0 D0 B sky130_fd_pr__pfet_01v8_lvt ad=0.58 pd=4.29 as=1.16 ps=8.58 w=4 l=0.35
C0 a_99_n400# S1 0.23983f
C1 G1 B 0.19252f
C2 S1 G0 0.10872f
C3 D0 B 0.246f
C4 a_99_n400# G1 0.10872f
C5 a_99_n400# B 0.246f
C6 G1 S1 0.10872f
C7 G1 G0 0.05517f
C8 S1 B 0.08953f
C9 B G0 0.19252f
C10 D0 S1 0.23983f
C11 D0 G0 0.10872f
C12 S1 VSUBS 0.06111f
C13 D0 VSUBS 0.14023f
C14 B VSUBS 2.784f
C15 a_99_n400# VSUBS 0.14023f
.ends

.subckt sky130_fd_pr__pfet_01v8_lvt_65C8BA B D0 G0 S1 G1 D2 G2 S3 G3 a_227_n400# VSUBS
X0 S1 G0 D0 B sky130_fd_pr__pfet_01v8_lvt ad=0.58 pd=4.29 as=1.16 ps=8.58 w=4 l=0.35
X1 a_227_n400# G3 S3 B sky130_fd_pr__pfet_01v8_lvt ad=1.16 pd=8.58 as=0.58 ps=4.29 w=4 l=0.35
X2 S3 G2 D2 B sky130_fd_pr__pfet_01v8_lvt ad=0.58 pd=4.29 as=0.58 ps=4.29 w=4 l=0.35
X3 D2 G1 S1 B sky130_fd_pr__pfet_01v8_lvt ad=0.58 pd=4.29 as=0.58 ps=4.29 w=4 l=0.35
C0 a_227_n400# S3 0.23983f
C1 D0 G0 0.10872f
C2 G1 S1 0.10872f
C3 B S1 0.08953f
C4 G3 S3 0.10872f
C5 S3 D2 0.23983f
C6 a_227_n400# G3 0.10872f
C7 G1 B 0.15546f
C8 D0 S1 0.23983f
C9 G2 G1 0.05517f
C10 G2 B 0.15546f
C11 D0 B 0.246f
C12 S3 B 0.08953f
C13 D2 S1 0.23983f
C14 G0 S1 0.10872f
C15 a_227_n400# B 0.246f
C16 G2 S3 0.10872f
C17 G1 D2 0.10872f
C18 G1 G0 0.05517f
C19 G3 B 0.19133f
C20 B D2 0.08953f
C21 B G0 0.19133f
C22 G2 G3 0.05517f
C23 G2 D2 0.10872f
C24 S3 VSUBS 0.04695f
C25 D2 VSUBS 0.0328f
C26 S1 VSUBS 0.04695f
C27 D0 VSUBS 0.14023f
C28 B VSUBS 3.81442f
C29 a_227_n400# VSUBS 0.14023f
.ends

.subckt sky130_fd_pr__nfet_01v8_ZXU89W B D0 G0 S1 G1 a_63_n400#
X0 a_63_n400# G1 S1 B sky130_fd_pr__nfet_01v8 ad=1.24 pd=8.62 as=0.66 ps=4.33 w=4 l=0.15
X1 S1 G0 D0 B sky130_fd_pr__nfet_01v8 ad=0.66 pd=4.33 as=1.24 ps=8.62 w=4 l=0.15
C0 S1 G0 0.05779f
C1 S1 a_63_n400# 0.32431f
C2 G1 a_63_n400# 0.05779f
C3 D0 G0 0.05779f
C4 S1 G1 0.05779f
C5 S1 D0 0.32431f
C6 S1 B 0.1906f
C7 D0 B 0.41609f
C8 a_63_n400# B 0.41609f
.ends

.subckt sky130_fd_pr__pfet_01v8_lvt_HGBDVL B D0 G0 S1 G1 D2 G2 S3 G3 D4 G4 S5 G5 D6
+ G6 S7 G7 a_483_n400# VSUBS
X0 S3 G2 D2 B sky130_fd_pr__pfet_01v8_lvt ad=0.58 pd=4.29 as=0.58 ps=4.29 w=4 l=0.35
X1 D6 G5 S5 B sky130_fd_pr__pfet_01v8_lvt ad=0.58 pd=4.29 as=0.58 ps=4.29 w=4 l=0.35
X2 D2 G1 S1 B sky130_fd_pr__pfet_01v8_lvt ad=0.58 pd=4.29 as=0.58 ps=4.29 w=4 l=0.35
X3 S5 G4 D4 B sky130_fd_pr__pfet_01v8_lvt ad=0.58 pd=4.29 as=0.58 ps=4.29 w=4 l=0.35
X4 S7 G6 D6 B sky130_fd_pr__pfet_01v8_lvt ad=0.58 pd=4.29 as=0.58 ps=4.29 w=4 l=0.35
X5 a_483_n400# G7 S7 B sky130_fd_pr__pfet_01v8_lvt ad=1.16 pd=8.58 as=0.58 ps=4.29 w=4 l=0.35
X6 D4 G3 S3 B sky130_fd_pr__pfet_01v8_lvt ad=0.58 pd=4.29 as=0.58 ps=4.29 w=4 l=0.35
X7 S1 G0 D0 B sky130_fd_pr__pfet_01v8_lvt ad=0.58 pd=4.29 as=1.16 ps=8.58 w=4 l=0.35
C0 B G6 0.15478f
C1 S7 G6 0.10872f
C2 S1 G1 0.10872f
C3 S5 G5 0.10872f
C4 B G3 0.15376f
C5 D0 G0 0.10872f
C6 D4 G3 0.10872f
C7 B a_483_n400# 0.246f
C8 B S3 0.08953f
C9 a_483_n400# S7 0.23983f
C10 B G1 0.15478f
C11 D4 S3 0.23983f
C12 G5 D6 0.10872f
C13 S1 G0 0.10872f
C14 G4 G5 0.05517f
C15 S5 B 0.08953f
C16 S5 D4 0.23983f
C17 B G0 0.19095f
C18 S3 G3 0.10872f
C19 B D6 0.08953f
C20 D6 S7 0.23983f
C21 G4 B 0.15376f
C22 G2 D2 0.10872f
C23 G4 D4 0.10872f
C24 D6 G6 0.10872f
C25 D0 S1 0.23983f
C26 S1 D2 0.23983f
C27 G1 G0 0.05517f
C28 G4 G3 0.05517f
C29 G5 B 0.154f
C30 D0 B 0.246f
C31 B D2 0.08953f
C32 B G7 0.19095f
C33 S7 G7 0.10872f
C34 G2 B 0.154f
C35 G5 G6 0.05517f
C36 B S1 0.08953f
C37 G6 G7 0.05517f
C38 S5 D6 0.23983f
C39 S5 G4 0.10872f
C40 G2 G3 0.05517f
C41 B S7 0.08953f
C42 D4 B 0.08953f
C43 D2 S3 0.23983f
C44 a_483_n400# G7 0.10872f
C45 D2 G1 0.10872f
C46 G2 S3 0.10872f
C47 G2 G1 0.05517f
C48 S7 VSUBS 0.04695f
C49 D6 VSUBS 0.0328f
C50 S5 VSUBS 0.0328f
C51 D4 VSUBS 0.0328f
C52 S3 VSUBS 0.0328f
C53 D2 VSUBS 0.0328f
C54 S1 VSUBS 0.04695f
C55 D0 VSUBS 0.14023f
C56 B VSUBS 5.88006f
C57 a_483_n400# VSUBS 0.14023f
.ends

.subckt sky130_fd_pr__nfet_01v8_TB4QGU B D0 G0 S1 G1 D2 G2 S3 G3 a_159_n400#
X0 S3 G2 D2 B sky130_fd_pr__nfet_01v8 ad=0.66 pd=4.33 as=0.66 ps=4.33 w=4 l=0.15
X1 S1 G0 D0 B sky130_fd_pr__nfet_01v8 ad=0.66 pd=4.33 as=1.24 ps=8.62 w=4 l=0.15
X2 D2 G1 S1 B sky130_fd_pr__nfet_01v8 ad=0.66 pd=4.33 as=0.66 ps=4.33 w=4 l=0.15
X3 a_159_n400# G3 S3 B sky130_fd_pr__nfet_01v8 ad=1.24 pd=8.62 as=0.66 ps=4.33 w=4 l=0.15
C0 S1 D0 0.32431f
C1 a_159_n400# S3 0.32431f
C2 G0 D0 0.05779f
C3 G3 S3 0.05779f
C4 D2 S3 0.32431f
C5 G3 G1 0.01248f
C6 D2 S1 0.32431f
C7 D2 G1 0.05779f
C8 D2 G2 0.05779f
C9 a_159_n400# G3 0.05779f
C10 G2 S3 0.05779f
C11 G0 S1 0.05779f
C12 S1 G1 0.05779f
C13 G0 G2 0.01248f
C14 S3 B 0.16676f
C15 D2 B 0.1611f
C16 S1 B 0.16676f
C17 D0 B 0.407f
C18 a_159_n400# B 0.407f
.ends

.subckt cdac dn2 dn5 dn6 dn7 vtop VDD dn4 MP7/D6 MN5/D dn1 dn3 MP6/D2 Vref dn0 VSS
XMP0 Vref MP0/D Vref dn0 VSS sky130_fd_pr__pfet_01v8_lvt_TEQ27F
XMP1 Vref MP1/D Vref dn1 VSS sky130_fd_pr__pfet_01v8_lvt_TEQ27F
XMN0 VSS MP0/D VSS dn0 sky130_fd_pr__nfet_01v8_PHAC7Z
XMP2 Vref MP2/D Vref dn2 VSS sky130_fd_pr__pfet_01v8_lvt_TEQ27F
XMN1 VSS MP1/D VSS dn1 sky130_fd_pr__nfet_01v8_PHAC7Z
XMP3 Vref MP3/D Vref dn3 VSS sky130_fd_pr__pfet_01v8_lvt_TEQ27F
XMN2 VSS MP2/D VSS dn2 sky130_fd_pr__nfet_01v8_PHAC7Z
XMP4 Vref MP4/D Vref dn4 VSS sky130_fd_pr__pfet_01v8_lvt_DQLGWQ
XMN3 VSS MP3/D VSS dn3 sky130_fd_pr__nfet_01v8_PHAC7Z
XMP5 Vref MN5/D dn5 Vref dn5 MN5/D VSS sky130_fd_pr__pfet_01v8_lvt_EXY38E
XMP6 Vref MP6/D2 dn6 Vref dn6 MP6/D2 dn6 Vref dn6 MP6/D2 VSS sky130_fd_pr__pfet_01v8_lvt_65C8BA
XMN4 VSS MP4/D VSS dn4 sky130_fd_pr__nfet_01v8_NK2ZG9
XMN5 VSS MN5/D VSS dn5 sky130_fd_pr__nfet_01v8_JSF6K7
XMN6 VSS MP6/D2 dn6 VSS dn6 MP6/D2 sky130_fd_pr__nfet_01v8_ZXU89W
XMP7 Vref MP7/D6 dn7 Vref dn7 MP7/D6 dn7 Vref dn7 MP7/D6 dn7 Vref dn7 MP7/D6 dn7 Vref
+ dn7 MP7/D6 VSS sky130_fd_pr__pfet_01v8_lvt_HGBDVL
XMN7 VSS MP7/D6 dn7 VSS dn7 MP7/D6 dn7 VSS dn7 MP7/D6 sky130_fd_pr__nfet_01v8_TB4QGU
X0 vtop MN5/D sky130_fd_pr__cap_mim_m3_1 l=2 w=2
X1 vtop MP3/D sky130_fd_pr__cap_mim_m3_1 l=2 w=2
X2 vtop MP6/D2 sky130_fd_pr__cap_mim_m3_1 l=2 w=2
X3 vtop MP7/D6 sky130_fd_pr__cap_mim_m3_1 l=2 w=2
X4 vtop MN5/D sky130_fd_pr__cap_mim_m3_1 l=2 w=2
X5 vtop MP7/D6 sky130_fd_pr__cap_mim_m3_1 l=2 w=2
X6 vtop MP7/D6 sky130_fd_pr__cap_mim_m3_1 l=2 w=2
X7 vtop MP7/D6 sky130_fd_pr__cap_mim_m3_1 l=2 w=2
X8 vtop MP6/D2 sky130_fd_pr__cap_mim_m3_1 l=2 w=2
X9 vtop MP4/D sky130_fd_pr__cap_mim_m3_1 l=2 w=2
X10 vtop MP7/D6 sky130_fd_pr__cap_mim_m3_1 l=2 w=2
X11 vtop MP6/D2 sky130_fd_pr__cap_mim_m3_1 l=2 w=2
X12 vtop MP7/D6 sky130_fd_pr__cap_mim_m3_1 l=2 w=2
X13 vtop MP6/D2 sky130_fd_pr__cap_mim_m3_1 l=2 w=2
X14 vtop MP6/D2 sky130_fd_pr__cap_mim_m3_1 l=2 w=2
X15 vtop MN5/D sky130_fd_pr__cap_mim_m3_1 l=2 w=2
X16 vtop MN5/D sky130_fd_pr__cap_mim_m3_1 l=2 w=2
X17 vtop MP3/D sky130_fd_pr__cap_mim_m3_1 l=2 w=2
X18 vtop MP7/D6 sky130_fd_pr__cap_mim_m3_1 l=2 w=2
X19 vtop MN5/D sky130_fd_pr__cap_mim_m3_1 l=2 w=2
X20 vtop MP7/D6 sky130_fd_pr__cap_mim_m3_1 l=2 w=2
X21 vtop MP4/D sky130_fd_pr__cap_mim_m3_1 l=2 w=2
X22 vtop MP6/D2 sky130_fd_pr__cap_mim_m3_1 l=2 w=2
X23 vtop MP7/D6 sky130_fd_pr__cap_mim_m3_1 l=2 w=2
X24 vtop MP7/D6 sky130_fd_pr__cap_mim_m3_1 l=2 w=2
X25 vtop MP7/D6 sky130_fd_pr__cap_mim_m3_1 l=2 w=2
X26 vtop MP7/D6 sky130_fd_pr__cap_mim_m3_1 l=2 w=2
X27 vtop MN5/D sky130_fd_pr__cap_mim_m3_1 l=2 w=2
X28 vtop MP7/D6 sky130_fd_pr__cap_mim_m3_1 l=2 w=2
X29 vtop MP7/D6 sky130_fd_pr__cap_mim_m3_1 l=2 w=2
X30 vtop MP7/D6 sky130_fd_pr__cap_mim_m3_1 l=2 w=2
X31 vtop MP6/D2 sky130_fd_pr__cap_mim_m3_1 l=2 w=2
X32 vtop MP7/D6 sky130_fd_pr__cap_mim_m3_1 l=2 w=2
X33 vtop VSS sky130_fd_pr__cap_mim_m3_1 l=2 w=2
X34 vtop MP6/D2 sky130_fd_pr__cap_mim_m3_1 l=2 w=2
X35 vtop MN5/D sky130_fd_pr__cap_mim_m3_1 l=2 w=2
X36 vtop MP7/D6 sky130_fd_pr__cap_mim_m3_1 l=2 w=2
X37 vtop MP7/D6 sky130_fd_pr__cap_mim_m3_1 l=2 w=2
X38 vtop MP7/D6 sky130_fd_pr__cap_mim_m3_1 l=2 w=2
X39 vtop MP7/D6 sky130_fd_pr__cap_mim_m3_1 l=2 w=2
X40 vtop MP3/D sky130_fd_pr__cap_mim_m3_1 l=2 w=2
X41 vtop MN5/D sky130_fd_pr__cap_mim_m3_1 l=2 w=2
X42 vtop MP7/D6 sky130_fd_pr__cap_mim_m3_1 l=2 w=2
X43 vtop MP6/D2 sky130_fd_pr__cap_mim_m3_1 l=2 w=2
X44 vtop MP7/D6 sky130_fd_pr__cap_mim_m3_1 l=2 w=2
X45 vtop MP7/D6 sky130_fd_pr__cap_mim_m3_1 l=2 w=2
X46 vtop MP7/D6 sky130_fd_pr__cap_mim_m3_1 l=2 w=2
X47 vtop MP7/D6 sky130_fd_pr__cap_mim_m3_1 l=2 w=2
X48 vtop MP6/D2 sky130_fd_pr__cap_mim_m3_1 l=2 w=2
X49 vtop MP6/D2 sky130_fd_pr__cap_mim_m3_1 l=2 w=2
X50 vtop MP6/D2 sky130_fd_pr__cap_mim_m3_1 l=2 w=2
X51 vtop MP7/D6 sky130_fd_pr__cap_mim_m3_1 l=2 w=2
X52 vtop MP3/D sky130_fd_pr__cap_mim_m3_1 l=2 w=2
X53 vtop MP6/D2 sky130_fd_pr__cap_mim_m3_1 l=2 w=2
X54 vtop MP7/D6 sky130_fd_pr__cap_mim_m3_1 l=2 w=2
X55 vtop MP7/D6 sky130_fd_pr__cap_mim_m3_1 l=2 w=2
X56 vtop MP7/D6 sky130_fd_pr__cap_mim_m3_1 l=2 w=2
X57 vtop MP7/D6 sky130_fd_pr__cap_mim_m3_1 l=2 w=2
X58 vtop MP6/D2 sky130_fd_pr__cap_mim_m3_1 l=2 w=2
X59 vtop MN5/D sky130_fd_pr__cap_mim_m3_1 l=2 w=2
X60 vtop MP7/D6 sky130_fd_pr__cap_mim_m3_1 l=2 w=2
X61 vtop MP6/D2 sky130_fd_pr__cap_mim_m3_1 l=2 w=2
X62 vtop MP7/D6 sky130_fd_pr__cap_mim_m3_1 l=2 w=2
X63 vtop MP7/D6 sky130_fd_pr__cap_mim_m3_1 l=2 w=2
X64 vtop MP6/D2 sky130_fd_pr__cap_mim_m3_1 l=2 w=2
X65 vtop MP6/D2 sky130_fd_pr__cap_mim_m3_1 l=2 w=2
X66 vtop MP6/D2 sky130_fd_pr__cap_mim_m3_1 l=2 w=2
X67 vtop MN5/D sky130_fd_pr__cap_mim_m3_1 l=2 w=2
X68 vtop MP7/D6 sky130_fd_pr__cap_mim_m3_1 l=2 w=2
X69 vtop MP7/D6 sky130_fd_pr__cap_mim_m3_1 l=2 w=2
X70 vtop MN5/D sky130_fd_pr__cap_mim_m3_1 l=2 w=2
X71 vtop MP7/D6 sky130_fd_pr__cap_mim_m3_1 l=2 w=2
X72 vtop MP4/D sky130_fd_pr__cap_mim_m3_1 l=2 w=2
X73 vtop MP7/D6 sky130_fd_pr__cap_mim_m3_1 l=2 w=2
X74 vtop MP6/D2 sky130_fd_pr__cap_mim_m3_1 l=2 w=2
X75 vtop MP7/D6 sky130_fd_pr__cap_mim_m3_1 l=2 w=2
X76 vtop MP2/D sky130_fd_pr__cap_mim_m3_1 l=2 w=2
X77 vtop MN5/D sky130_fd_pr__cap_mim_m3_1 l=2 w=2
X78 vtop MP6/D2 sky130_fd_pr__cap_mim_m3_1 l=2 w=2
X79 vtop MP7/D6 sky130_fd_pr__cap_mim_m3_1 l=2 w=2
X80 vtop MP7/D6 sky130_fd_pr__cap_mim_m3_1 l=2 w=2
X81 vtop MN5/D sky130_fd_pr__cap_mim_m3_1 l=2 w=2
X82 vtop MN5/D sky130_fd_pr__cap_mim_m3_1 l=2 w=2
X83 vtop MN5/D sky130_fd_pr__cap_mim_m3_1 l=2 w=2
X84 vtop MP4/D sky130_fd_pr__cap_mim_m3_1 l=2 w=2
X85 vtop MP7/D6 sky130_fd_pr__cap_mim_m3_1 l=2 w=2
X86 vtop MP7/D6 sky130_fd_pr__cap_mim_m3_1 l=2 w=2
X87 vtop MP6/D2 sky130_fd_pr__cap_mim_m3_1 l=2 w=2
X88 vtop MP6/D2 sky130_fd_pr__cap_mim_m3_1 l=2 w=2
X89 vtop MP4/D sky130_fd_pr__cap_mim_m3_1 l=2 w=2
X90 vtop MP7/D6 sky130_fd_pr__cap_mim_m3_1 l=2 w=2
X91 vtop MP7/D6 sky130_fd_pr__cap_mim_m3_1 l=2 w=2
X92 vtop MP4/D sky130_fd_pr__cap_mim_m3_1 l=2 w=2
X93 vtop MP7/D6 sky130_fd_pr__cap_mim_m3_1 l=2 w=2
X94 vtop MP7/D6 sky130_fd_pr__cap_mim_m3_1 l=2 w=2
X95 vtop MP7/D6 sky130_fd_pr__cap_mim_m3_1 l=2 w=2
X96 vtop MP3/D sky130_fd_pr__cap_mim_m3_1 l=2 w=2
X97 vtop MP6/D2 sky130_fd_pr__cap_mim_m3_1 l=2 w=2
X98 vtop MP7/D6 sky130_fd_pr__cap_mim_m3_1 l=2 w=2
X99 vtop MP7/D6 sky130_fd_pr__cap_mim_m3_1 l=2 w=2
X100 vtop MP7/D6 sky130_fd_pr__cap_mim_m3_1 l=2 w=2
X101 vtop MP7/D6 sky130_fd_pr__cap_mim_m3_1 l=2 w=2
X102 vtop MP7/D6 sky130_fd_pr__cap_mim_m3_1 l=2 w=2
X103 vtop MP7/D6 sky130_fd_pr__cap_mim_m3_1 l=2 w=2
X104 vtop MP6/D2 sky130_fd_pr__cap_mim_m3_1 l=2 w=2
X105 vtop MP6/D2 sky130_fd_pr__cap_mim_m3_1 l=2 w=2
X106 vtop MN5/D sky130_fd_pr__cap_mim_m3_1 l=2 w=2
X107 vtop MP7/D6 sky130_fd_pr__cap_mim_m3_1 l=2 w=2
X108 vtop MP7/D6 sky130_fd_pr__cap_mim_m3_1 l=2 w=2
X109 vtop MP7/D6 sky130_fd_pr__cap_mim_m3_1 l=2 w=2
X110 vtop MN5/D sky130_fd_pr__cap_mim_m3_1 l=2 w=2
X111 vtop MP7/D6 sky130_fd_pr__cap_mim_m3_1 l=2 w=2
X112 vtop MP7/D6 sky130_fd_pr__cap_mim_m3_1 l=2 w=2
X113 vtop MP7/D6 sky130_fd_pr__cap_mim_m3_1 l=2 w=2
X114 vtop MP6/D2 sky130_fd_pr__cap_mim_m3_1 l=2 w=2
X115 vtop MN5/D sky130_fd_pr__cap_mim_m3_1 l=2 w=2
X116 vtop MN5/D sky130_fd_pr__cap_mim_m3_1 l=2 w=2
X117 vtop MP7/D6 sky130_fd_pr__cap_mim_m3_1 l=2 w=2
X118 vtop MP4/D sky130_fd_pr__cap_mim_m3_1 l=2 w=2
X119 vtop MP6/D2 sky130_fd_pr__cap_mim_m3_1 l=2 w=2
X120 vtop MP7/D6 sky130_fd_pr__cap_mim_m3_1 l=2 w=2
X121 vtop MP7/D6 sky130_fd_pr__cap_mim_m3_1 l=2 w=2
X122 vtop MP7/D6 sky130_fd_pr__cap_mim_m3_1 l=2 w=2
X123 vtop MN5/D sky130_fd_pr__cap_mim_m3_1 l=2 w=2
X124 vtop MP7/D6 sky130_fd_pr__cap_mim_m3_1 l=2 w=2
X125 vtop MP6/D2 sky130_fd_pr__cap_mim_m3_1 l=2 w=2
X126 vtop MP6/D2 sky130_fd_pr__cap_mim_m3_1 l=2 w=2
X127 vtop MP7/D6 sky130_fd_pr__cap_mim_m3_1 l=2 w=2
X128 vtop MP7/D6 sky130_fd_pr__cap_mim_m3_1 l=2 w=2
X129 vtop MP6/D2 sky130_fd_pr__cap_mim_m3_1 l=2 w=2
X130 vtop MP6/D2 sky130_fd_pr__cap_mim_m3_1 l=2 w=2
X131 vtop MP4/D sky130_fd_pr__cap_mim_m3_1 l=2 w=2
X132 vtop MP7/D6 sky130_fd_pr__cap_mim_m3_1 l=2 w=2
X133 vtop MP7/D6 sky130_fd_pr__cap_mim_m3_1 l=2 w=2
X134 vtop MP7/D6 sky130_fd_pr__cap_mim_m3_1 l=2 w=2
X135 vtop MP7/D6 sky130_fd_pr__cap_mim_m3_1 l=2 w=2
X136 vtop MP7/D6 sky130_fd_pr__cap_mim_m3_1 l=2 w=2
X137 vtop MP6/D2 sky130_fd_pr__cap_mim_m3_1 l=2 w=2
X138 vtop MP7/D6 sky130_fd_pr__cap_mim_m3_1 l=2 w=2
X139 vtop MP2/D sky130_fd_pr__cap_mim_m3_1 l=2 w=2
X140 vtop MP6/D2 sky130_fd_pr__cap_mim_m3_1 l=2 w=2
X141 vtop MN5/D sky130_fd_pr__cap_mim_m3_1 l=2 w=2
X142 vtop MN5/D sky130_fd_pr__cap_mim_m3_1 l=2 w=2
X143 vtop MP6/D2 sky130_fd_pr__cap_mim_m3_1 l=2 w=2
X144 vtop MP4/D sky130_fd_pr__cap_mim_m3_1 l=2 w=2
X145 vtop MP7/D6 sky130_fd_pr__cap_mim_m3_1 l=2 w=2
X146 vtop MP2/D sky130_fd_pr__cap_mim_m3_1 l=2 w=2
X147 vtop MP7/D6 sky130_fd_pr__cap_mim_m3_1 l=2 w=2
X148 vtop MP7/D6 sky130_fd_pr__cap_mim_m3_1 l=2 w=2
X149 vtop MP3/D sky130_fd_pr__cap_mim_m3_1 l=2 w=2
X150 vtop MN5/D sky130_fd_pr__cap_mim_m3_1 l=2 w=2
X151 vtop MP6/D2 sky130_fd_pr__cap_mim_m3_1 l=2 w=2
X152 vtop MP7/D6 sky130_fd_pr__cap_mim_m3_1 l=2 w=2
X153 vtop MP7/D6 sky130_fd_pr__cap_mim_m3_1 l=2 w=2
X154 vtop MN5/D sky130_fd_pr__cap_mim_m3_1 l=2 w=2
X155 vtop MP7/D6 sky130_fd_pr__cap_mim_m3_1 l=2 w=2
X156 vtop MP4/D sky130_fd_pr__cap_mim_m3_1 l=2 w=2
X157 vtop MN5/D sky130_fd_pr__cap_mim_m3_1 l=2 w=2
X158 vtop MP6/D2 sky130_fd_pr__cap_mim_m3_1 l=2 w=2
X159 vtop MP7/D6 sky130_fd_pr__cap_mim_m3_1 l=2 w=2
X160 vtop MP7/D6 sky130_fd_pr__cap_mim_m3_1 l=2 w=2
X161 vtop MP4/D sky130_fd_pr__cap_mim_m3_1 l=2 w=2
X162 vtop MP6/D2 sky130_fd_pr__cap_mim_m3_1 l=2 w=2
X163 vtop MP7/D6 sky130_fd_pr__cap_mim_m3_1 l=2 w=2
X164 vtop MP7/D6 sky130_fd_pr__cap_mim_m3_1 l=2 w=2
X165 vtop MP7/D6 sky130_fd_pr__cap_mim_m3_1 l=2 w=2
X166 vtop MP7/D6 sky130_fd_pr__cap_mim_m3_1 l=2 w=2
X167 vtop MP7/D6 sky130_fd_pr__cap_mim_m3_1 l=2 w=2
X168 vtop MP7/D6 sky130_fd_pr__cap_mim_m3_1 l=2 w=2
X169 vtop MN5/D sky130_fd_pr__cap_mim_m3_1 l=2 w=2
X170 vtop MP7/D6 sky130_fd_pr__cap_mim_m3_1 l=2 w=2
X171 vtop MP6/D2 sky130_fd_pr__cap_mim_m3_1 l=2 w=2
X172 vtop MP4/D sky130_fd_pr__cap_mim_m3_1 l=2 w=2
X173 vtop MP7/D6 sky130_fd_pr__cap_mim_m3_1 l=2 w=2
X174 vtop MP6/D2 sky130_fd_pr__cap_mim_m3_1 l=2 w=2
X175 vtop MP7/D6 sky130_fd_pr__cap_mim_m3_1 l=2 w=2
X176 vtop MP7/D6 sky130_fd_pr__cap_mim_m3_1 l=2 w=2
X177 vtop MP7/D6 sky130_fd_pr__cap_mim_m3_1 l=2 w=2
X178 vtop MP6/D2 sky130_fd_pr__cap_mim_m3_1 l=2 w=2
X179 vtop MP6/D2 sky130_fd_pr__cap_mim_m3_1 l=2 w=2
X180 vtop MP7/D6 sky130_fd_pr__cap_mim_m3_1 l=2 w=2
X181 vtop MP4/D sky130_fd_pr__cap_mim_m3_1 l=2 w=2
X182 vtop MP6/D2 sky130_fd_pr__cap_mim_m3_1 l=2 w=2
X183 vtop MP7/D6 sky130_fd_pr__cap_mim_m3_1 l=2 w=2
X184 vtop MP1/D sky130_fd_pr__cap_mim_m3_1 l=2 w=2
X185 vtop MP7/D6 sky130_fd_pr__cap_mim_m3_1 l=2 w=2
X186 vtop MP7/D6 sky130_fd_pr__cap_mim_m3_1 l=2 w=2
X187 vtop MP6/D2 sky130_fd_pr__cap_mim_m3_1 l=2 w=2
X188 vtop MP7/D6 sky130_fd_pr__cap_mim_m3_1 l=2 w=2
X189 vtop MP6/D2 sky130_fd_pr__cap_mim_m3_1 l=2 w=2
X190 vtop MP7/D6 sky130_fd_pr__cap_mim_m3_1 l=2 w=2
X191 vtop MP6/D2 sky130_fd_pr__cap_mim_m3_1 l=2 w=2
X192 vtop MP6/D2 sky130_fd_pr__cap_mim_m3_1 l=2 w=2
X193 vtop MP7/D6 sky130_fd_pr__cap_mim_m3_1 l=2 w=2
X194 vtop MP6/D2 sky130_fd_pr__cap_mim_m3_1 l=2 w=2
X195 vtop MP4/D sky130_fd_pr__cap_mim_m3_1 l=2 w=2
X196 vtop MP7/D6 sky130_fd_pr__cap_mim_m3_1 l=2 w=2
X197 vtop MP6/D2 sky130_fd_pr__cap_mim_m3_1 l=2 w=2
X198 vtop MP7/D6 sky130_fd_pr__cap_mim_m3_1 l=2 w=2
X199 vtop MP3/D sky130_fd_pr__cap_mim_m3_1 l=2 w=2
X200 vtop MP6/D2 sky130_fd_pr__cap_mim_m3_1 l=2 w=2
X201 vtop MP7/D6 sky130_fd_pr__cap_mim_m3_1 l=2 w=2
X202 vtop MP6/D2 sky130_fd_pr__cap_mim_m3_1 l=2 w=2
X203 vtop MN5/D sky130_fd_pr__cap_mim_m3_1 l=2 w=2
X204 vtop MP6/D2 sky130_fd_pr__cap_mim_m3_1 l=2 w=2
X205 vtop MN5/D sky130_fd_pr__cap_mim_m3_1 l=2 w=2
X206 vtop MP7/D6 sky130_fd_pr__cap_mim_m3_1 l=2 w=2
X207 vtop MP2/D sky130_fd_pr__cap_mim_m3_1 l=2 w=2
X208 vtop MP7/D6 sky130_fd_pr__cap_mim_m3_1 l=2 w=2
X209 vtop MP7/D6 sky130_fd_pr__cap_mim_m3_1 l=2 w=2
X210 vtop MP7/D6 sky130_fd_pr__cap_mim_m3_1 l=2 w=2
X211 vtop MP6/D2 sky130_fd_pr__cap_mim_m3_1 l=2 w=2
X212 vtop MN5/D sky130_fd_pr__cap_mim_m3_1 l=2 w=2
X213 vtop MP6/D2 sky130_fd_pr__cap_mim_m3_1 l=2 w=2
X214 vtop MP7/D6 sky130_fd_pr__cap_mim_m3_1 l=2 w=2
X215 vtop MP6/D2 sky130_fd_pr__cap_mim_m3_1 l=2 w=2
X216 vtop MP3/D sky130_fd_pr__cap_mim_m3_1 l=2 w=2
X217 vtop MN5/D sky130_fd_pr__cap_mim_m3_1 l=2 w=2
X218 vtop MP7/D6 sky130_fd_pr__cap_mim_m3_1 l=2 w=2
X219 vtop MP6/D2 sky130_fd_pr__cap_mim_m3_1 l=2 w=2
X220 vtop MP7/D6 sky130_fd_pr__cap_mim_m3_1 l=2 w=2
X221 vtop MN5/D sky130_fd_pr__cap_mim_m3_1 l=2 w=2
X222 vtop MP7/D6 sky130_fd_pr__cap_mim_m3_1 l=2 w=2
X223 vtop MP7/D6 sky130_fd_pr__cap_mim_m3_1 l=2 w=2
X224 vtop MP7/D6 sky130_fd_pr__cap_mim_m3_1 l=2 w=2
X225 vtop MP4/D sky130_fd_pr__cap_mim_m3_1 l=2 w=2
X226 vtop MP6/D2 sky130_fd_pr__cap_mim_m3_1 l=2 w=2
X227 vtop MP7/D6 sky130_fd_pr__cap_mim_m3_1 l=2 w=2
X228 vtop MP0/D sky130_fd_pr__cap_mim_m3_1 l=2 w=2
X229 vtop MP7/D6 sky130_fd_pr__cap_mim_m3_1 l=2 w=2
X230 vtop MP7/D6 sky130_fd_pr__cap_mim_m3_1 l=2 w=2
X231 vtop MP7/D6 sky130_fd_pr__cap_mim_m3_1 l=2 w=2
X232 vtop MP6/D2 sky130_fd_pr__cap_mim_m3_1 l=2 w=2
X233 vtop MP7/D6 sky130_fd_pr__cap_mim_m3_1 l=2 w=2
X234 vtop MP6/D2 sky130_fd_pr__cap_mim_m3_1 l=2 w=2
X235 vtop MP4/D sky130_fd_pr__cap_mim_m3_1 l=2 w=2
X236 vtop MP7/D6 sky130_fd_pr__cap_mim_m3_1 l=2 w=2
X237 vtop MP7/D6 sky130_fd_pr__cap_mim_m3_1 l=2 w=2
X238 vtop MP7/D6 sky130_fd_pr__cap_mim_m3_1 l=2 w=2
X239 vtop MP6/D2 sky130_fd_pr__cap_mim_m3_1 l=2 w=2
X240 vtop MP7/D6 sky130_fd_pr__cap_mim_m3_1 l=2 w=2
X241 vtop MP7/D6 sky130_fd_pr__cap_mim_m3_1 l=2 w=2
X242 vtop MP6/D2 sky130_fd_pr__cap_mim_m3_1 l=2 w=2
X243 vtop MP7/D6 sky130_fd_pr__cap_mim_m3_1 l=2 w=2
X244 vtop MP1/D sky130_fd_pr__cap_mim_m3_1 l=2 w=2
X245 vtop MP6/D2 sky130_fd_pr__cap_mim_m3_1 l=2 w=2
X246 vtop MP7/D6 sky130_fd_pr__cap_mim_m3_1 l=2 w=2
X247 vtop MP7/D6 sky130_fd_pr__cap_mim_m3_1 l=2 w=2
X248 vtop MP7/D6 sky130_fd_pr__cap_mim_m3_1 l=2 w=2
X249 vtop MP6/D2 sky130_fd_pr__cap_mim_m3_1 l=2 w=2
X250 vtop MP6/D2 sky130_fd_pr__cap_mim_m3_1 l=2 w=2
X251 vtop MN5/D sky130_fd_pr__cap_mim_m3_1 l=2 w=2
X252 vtop MP7/D6 sky130_fd_pr__cap_mim_m3_1 l=2 w=2
X253 vtop MP7/D6 sky130_fd_pr__cap_mim_m3_1 l=2 w=2
X254 vtop MP6/D2 sky130_fd_pr__cap_mim_m3_1 l=2 w=2
X255 vtop MP7/D6 sky130_fd_pr__cap_mim_m3_1 l=2 w=2
C0 MN5/D MP6/D2 1.80294f
C1 MP7/D6 MP0/D 0.06317f
C2 MP1/D MP4/D 0.70972f
C3 MP7/D6 dn0 0.01823f
C4 MN5/D Vref 0.36963f
C5 vtop MP2/D 2.83305f
C6 MP0/D dn1 0.05312f
C7 dn1 dn0 0.02003f
C8 Vref MP6/D2 0.60046f
C9 MP7/D6 MP3/D 0.0431f
C10 MP2/D MP4/D 1.11266f
C11 MP3/D dn3 0.39685f
C12 MN5/D MP1/D 1.40562f
C13 MP0/D dn0 0.41364f
C14 MP1/D MP6/D2 0.06284f
C15 vtop MP7/D6 0.1105p
C16 Vref MP1/D 0.12857f
C17 MP3/D MP0/D 0.13284f
C18 MP7/D6 dn4 0.01013f
C19 MN5/D MP2/D 1.85854f
C20 MP7/D6 MP4/D 0.0556f
C21 MP2/D MP6/D2 0.17608f
C22 dn2 Vref 0.33479f
C23 dn4 dn5 0.03344f
C24 dn7 MP6/D2 0.01662f
C25 vtop MP0/D 0.77067f
C26 MP2/D Vref 0.12638f
C27 Vref dn7 0.72805f
C28 dn5 MP4/D 0.04217f
C29 dn6 MN5/D 0.07413f
C30 MP7/D6 MN5/D 0.05973f
C31 dn2 MP1/D 0.0542f
C32 MP0/D MP4/D 0.2584f
C33 vtop MP3/D 5.53509f
C34 MP2/D MP1/D 0.75641f
C35 dn6 MP6/D2 0.61676f
C36 MP3/D dn4 0.04114f
C37 MP7/D6 MP6/D2 2.57196f
C38 dn6 Vref 0.50499f
C39 MN5/D dn5 0.51006f
C40 MP7/D6 Vref 1.07761f
C41 MP3/D MP4/D 2.29734f
C42 dn2 MP2/D 0.39848f
C43 dn3 Vref 0.34757f
C44 MN5/D MP0/D 0.58289f
C45 dn1 Vref 0.33995f
C46 Vref dn5 0.46481f
C47 MP0/D MP6/D2 0.78484f
C48 MP7/D6 MP1/D 0.0395f
C49 vtop MP4/D 12.4739f
C50 MP0/D Vref 0.14774f
C51 MP3/D MN5/D 1.52911f
C52 dn0 Vref 0.21043f
C53 dn1 MP1/D 0.39591f
C54 dn4 MP4/D 0.52787f
C55 MP7/D6 dn2 0.01692f
C56 MP3/D MP6/D2 0.29544f
C57 MP7/D6 MP2/D 0.04731f
C58 dn3 dn2 0.0196f
C59 MP3/D Vref 0.12972f
C60 MP0/D MP1/D 0.15582f
C61 dn6 dn7 0.01272f
C62 MP7/D6 dn7 0.98876f
C63 vtop MN5/D 26.3914f
C64 dn1 dn2 0.01949f
C65 dn3 MP2/D 0.05355f
C66 vtop MP6/D2 49.5246f
C67 MP3/D MP1/D 0.40011f
C68 MN5/D MP4/D 3.83041f
C69 MP0/D MP2/D 0.05396f
C70 dn6 MP7/D6 0.0781f
C71 dn4 Vref 0.38859f
C72 MP4/D MP6/D2 0.86462f
C73 MP7/D6 dn3 0.01692f
C74 Vref MP4/D 0.18683f
C75 vtop MP1/D 1.13335f
C76 MP7/D6 dn1 0.01691f
C77 MP3/D MP2/D 2.33304f
C78 dn6 dn5 0.02861f
C79 VDD VSS 0.07989f
C80 dn5 VSS 0.26801f
C81 dn0 VSS 0.47488f
C82 dn1 VSS 0.29273f
C83 dn2 VSS 0.28735f
C84 dn3 VSS 0.29772f
C85 dn4 VSS 0.32146f
C86 MP7/D6 VSS 35.15958f
C87 dn7 VSS 1.24142f
C88 Vref VSS -0.57381f
C89 MP6/D2 VSS 15.35524f
C90 dn6 VSS 0.84104f
C91 MN5/D VSS 31.47819f
C92 MP4/D VSS 5.52403f
C93 MP3/D VSS 4.03726f
C94 MP2/D VSS 2.86201f
C95 MP1/D VSS 3.45233f
C96 MP0/D VSS 3.95734f
.ends

.subckt sky130_fd_pr__nfet_01v8_WLECUA B D0 G0 S1 G1 D2 G2 S3 G3 D4 G4 S5 G5 D6 G6
+ S7 G7 a_4203_n1000#
X0 S7 G6 D6 B sky130_fd_pr__nfet_01v8 ad=1.45 pd=10.29 as=1.45 ps=10.29 w=10 l=5
X1 S5 G4 D4 B sky130_fd_pr__nfet_01v8 ad=1.45 pd=10.29 as=1.45 ps=10.29 w=10 l=5
X2 D2 G1 S1 B sky130_fd_pr__nfet_01v8 ad=1.45 pd=10.29 as=1.45 ps=10.29 w=10 l=5
X3 D4 G3 S3 B sky130_fd_pr__nfet_01v8 ad=1.45 pd=10.29 as=1.45 ps=10.29 w=10 l=5
X4 a_4203_n1000# G7 S7 B sky130_fd_pr__nfet_01v8 ad=2.9 pd=20.58 as=1.45 ps=10.29 w=10 l=5
X5 S1 G0 D0 B sky130_fd_pr__nfet_01v8 ad=1.45 pd=10.29 as=2.9 ps=20.58 w=10 l=5
X6 D6 G5 S5 B sky130_fd_pr__nfet_01v8 ad=1.45 pd=10.29 as=1.45 ps=10.29 w=10 l=5
X7 S3 G2 D2 B sky130_fd_pr__nfet_01v8 ad=1.45 pd=10.29 as=1.45 ps=10.29 w=10 l=5
C0 G3 D4 0.84307f
C1 D6 G5 0.84307f
C2 G2 S3 0.84307f
C3 G4 G5 0.05269f
C4 S1 G1 0.84307f
C5 G6 D6 0.84307f
C6 G1 G2 0.05269f
C7 D6 S7 0.06802f
C8 G4 D4 0.84307f
C9 S3 D4 0.06802f
C10 D6 S5 0.06802f
C11 G4 S5 0.84307f
C12 G6 G5 0.05269f
C13 G4 G3 0.05269f
C14 G3 S3 0.84307f
C15 D0 G0 0.84307f
C16 G6 G7 0.05269f
C17 G6 S7 0.84307f
C18 G3 G2 0.05269f
C19 S1 G0 0.84307f
C20 S5 G5 0.84307f
C21 G7 S7 0.84307f
C22 S1 D2 0.06802f
C23 D2 S3 0.06802f
C24 S1 D0 0.06802f
C25 G7 a_4203_n1000# 0.84307f
C26 G0 G1 0.05269f
C27 D2 G2 0.84307f
C28 D2 G1 0.84307f
C29 a_4203_n1000# S7 0.06802f
C30 S5 D4 0.06802f
C31 S7 B 2.03595f
C32 D6 B 2.00106f
C33 S5 B 2.00084f
C34 D4 B 2.00084f
C35 S3 B 2.00084f
C36 D2 B 2.00106f
C37 S1 B 2.03595f
C38 D0 B 1.80064f
C39 a_4203_n1000# B 1.80064f
.ends

.subckt decap Vref VSS
XMC0 VSS VSS Vref VSS Vref VSS Vref VSS Vref VSS Vref VSS Vref VSS Vref VSS Vref VSS
+ sky130_fd_pr__nfet_01v8_WLECUA
XMC1 VSS VSS Vref VSS Vref VSS Vref VSS Vref VSS Vref VSS Vref VSS Vref VSS Vref VSS
+ sky130_fd_pr__nfet_01v8_WLECUA
XMC2 VSS VSS Vref VSS Vref VSS Vref VSS Vref VSS Vref VSS Vref VSS Vref VSS Vref VSS
+ sky130_fd_pr__nfet_01v8_WLECUA
C0 Vref VSS 6.7344f
.ends

.subckt sky130_fd_pr__res_xhigh_po_1p41_BDUJGV B R1 R2
X0 R1 R2 B sky130_fd_pr__res_xhigh_po_1p41 l=36
C0 R2 B 0.66301f
C1 R1 B 0.66301f
.ends

.subckt sky130_fd_pr__cap_mim_m3_1_CGC2GW C2 C1 VSUBS
X0 C1 C2 sky130_fd_pr__cap_mim_m3_1 l=22 w=22
X1 C1 C2 sky130_fd_pr__cap_mim_m3_1 l=22 w=22
C0 C2 C1 85.55979f
C1 C2 VSUBS 25.05906f
.ends

.subckt vcm_gen vcm Vref VSS
XR1 VSS Vref vcm sky130_fd_pr__res_xhigh_po_1p41_BDUJGV
XR2 VSS VSS vcm sky130_fd_pr__res_xhigh_po_1p41_BDUJGV
XCcm VSS vcm VSS sky130_fd_pr__cap_mim_m3_1_CGC2GW
C0 vcm VSS 1.60505f
C1 Vref VSS 0.03349f
.ends

.subckt sky130_fd_pr__nfet_01v8_87U5T8 B D S G
X0 S G D B sky130_fd_pr__nfet_01v8 ad=0.58 pd=4.58 as=0.58 ps=4.58 w=2 l=0.6
C0 G D 0.08174f
C1 G S 0.08174f
C2 S D 0.08687f
C3 S B 0.37266f
C4 D B 0.37266f
.ends

.subckt sky130_fd_pr__nfet_01v8_F2GPUV B D S G
X0 S G D B sky130_fd_pr__nfet_01v8 ad=0.29 pd=2.58 as=0.29 ps=2.58 w=1 l=0.15
C0 G D 0.02676f
C1 G S 0.02676f
C2 S D 0.08701f
C3 S B 0.25019f
C4 D B 0.25019f
.ends

.subckt sky130_fd_pr__pfet_01v8_GJK8GW B D0 G0 S1 G1 D2 G2 S3 G3 a_287_n200# VSUBS
X0 S1 G0 D0 B sky130_fd_pr__pfet_01v8 ad=0.29 pd=2.29 as=0.58 ps=4.58 w=2 l=0.5
X1 a_287_n200# G3 S3 B sky130_fd_pr__pfet_01v8 ad=0.58 pd=4.58 as=0.29 ps=2.29 w=2 l=0.5
X2 S3 G2 D2 B sky130_fd_pr__pfet_01v8 ad=0.29 pd=2.29 as=0.29 ps=2.29 w=2 l=0.5
X3 D2 G1 S1 B sky130_fd_pr__pfet_01v8 ad=0.29 pd=2.29 as=0.29 ps=2.29 w=2 l=0.5
C0 S3 G3 0.07207f
C1 D0 B 0.1377f
C2 S3 G2 0.07207f
C3 a_287_n200# S3 0.09782f
C4 G1 G2 0.05517f
C5 S1 B 0.06308f
C6 G3 G2 0.05517f
C7 a_287_n200# G3 0.07207f
C8 S3 B 0.06308f
C9 D0 G0 0.07207f
C10 G1 B 0.20358f
C11 G3 B 0.24048f
C12 S1 D2 0.09782f
C13 S1 G0 0.07207f
C14 S3 D2 0.09782f
C15 G2 B 0.20358f
C16 D2 G1 0.07207f
C17 a_287_n200# B 0.1377f
C18 G1 G0 0.05517f
C19 D0 S1 0.09782f
C20 D2 G2 0.07207f
C21 S1 G1 0.07207f
C22 D2 B 0.06308f
C23 G0 B 0.24048f
C24 S3 VSUBS 0.05935f
C25 D2 VSUBS 0.0452f
C26 S1 VSUBS 0.05935f
C27 D0 VSUBS 0.09598f
C28 B VSUBS 3.00136f
C29 a_287_n200# VSUBS 0.09598f
.ends

.subckt sky130_fd_pr__nfet_01v8_6ZC5G7 B D S G
X0 S G D B sky130_fd_pr__nfet_01v8 ad=0.29 pd=2.58 as=0.29 ps=2.58 w=1 l=0.15
C0 G S 0.02676f
C1 D G 0.02676f
C2 D S 0.08701f
C3 S B 0.25019f
C4 D B 0.25019f
.ends

.subckt sky130_fd_pr__pfet_01v8_5YQU8J B D S G VSUBS
X0 S G D B sky130_fd_pr__pfet_01v8 ad=0.58 pd=4.58 as=0.58 ps=4.58 w=2 l=0.15
C0 G S 0.04023f
C1 B D 0.12129f
C2 G B 0.23095f
C3 B S 0.12129f
C4 G D 0.04023f
C5 D S 0.17277f
C6 S VSUBS 0.10779f
C7 D VSUBS 0.10779f
C8 B VSUBS 1.46341f
.ends

.subckt sky130_fd_pr__pfet_01v8_53SGHS B D S G VSUBS
X0 S G D B sky130_fd_pr__pfet_01v8 ad=0.58 pd=4.58 as=0.58 ps=4.58 w=2 l=0.15
C0 G S 0.04023f
C1 B D 0.12129f
C2 G B 0.23095f
C3 B S 0.12129f
C4 G D 0.04023f
C5 D S 0.17277f
C6 S VSUBS 0.10779f
C7 D VSUBS 0.10779f
C8 B VSUBS 1.46341f
.ends

.subckt sky130_fd_pr__pfet_01v8_WXVH9J B D S G VSUBS
X0 S G D B sky130_fd_pr__pfet_01v8 ad=1.16 pd=8.58 as=1.16 ps=8.58 w=4 l=0.15
C0 G S 0.06695f
C1 B D 0.22659f
C2 G B 0.23379f
C3 B S 0.22659f
C4 G D 0.06695f
C5 D S 0.3443f
C6 S VSUBS 0.1603f
C7 D VSUBS 0.1603f
C8 B VSUBS 2.11349f
.ends

.subckt comparator inp inn clk outp outn MB3/G S2/D S4/D MA3/G S4/G VDD S1/D VSS M7/D
XS1 VSS S1/D VSS S4/G sky130_fd_pr__nfet_01v8_87U5T8
XS2 VSS S2/D VSS S4/G sky130_fd_pr__nfet_01v8_87U5T8
XS3 VSS S3/D VSS S4/G sky130_fd_pr__nfet_01v8_87U5T8
XS4 VSS S4/D VSS S4/G sky130_fd_pr__nfet_01v8_87U5T8
XMI2N VSS MB3/G VSS S3/D sky130_fd_pr__nfet_01v8_F2GPUV
XM1 M7/D S1/D inp M7/D inp S1/D inp M7/D inp S1/D VSS sky130_fd_pr__pfet_01v8_GJK8GW
XMI1N VSS MA3/G VSS S4/D sky130_fd_pr__nfet_01v8_6ZC5G7
XMIN VSS S4/G VSS clk sky130_fd_pr__nfet_01v8_34VMYE
XM2 M7/D S2/D inn M7/D inn S2/D inn M7/D inn S2/D VSS sky130_fd_pr__pfet_01v8_GJK8GW
XMI1P VDD MA3/G VDD S4/D VSS sky130_fd_pr__pfet_01v8_5YQU8J
XMI2P VDD MB3/G VDD S3/D VSS sky130_fd_pr__pfet_01v8_53SGHS
XM4 VDD S4/D S2/D S3/D VSS sky130_fd_pr__pfet_01v8_VJT448
XM3 VDD S3/D S1/D S4/D VSS sky130_fd_pr__pfet_01v8_VJT448
XMIP VDD S4/G VDD clk VSS sky130_fd_pr__pfet_01v8_VJT448
XM5 VSS S3/D VSS S4/D sky130_fd_pr__nfet_01v8_34VMYE
XM6 VSS S4/D VSS S3/D sky130_fd_pr__nfet_01v8_34VMYE
XM7 VDD M7/D VDD S4/G VSS sky130_fd_pr__pfet_01v8_WXVH9J
XMB2 VDD outn VDD outp VSS sky130_fd_pr__pfet_01v8_7HN6Y2
XMB1 VDD outn VDD MB3/G VSS sky130_fd_pr__pfet_01v8_7HN6Y2
XMA1 VDD outp VDD MA3/G VSS sky130_fd_pr__pfet_01v8_7HN6Y2
XMB3 VSS outn MB4/D MB3/G sky130_fd_pr__nfet_01v8_NK2ZG9
XMA2 VDD outp VDD outn VSS sky130_fd_pr__pfet_01v8_7HN6Y2
XMA3 VSS outp MA4/D MA3/G sky130_fd_pr__nfet_01v8_NK2ZG9
XMB4 VSS MB4/D VSS outp sky130_fd_pr__nfet_01v8_NK2ZG9
XMA4 VSS MA4/D VSS outn sky130_fd_pr__nfet_01v8_NK2ZG9
C0 inp S4/G 0.06238f
C1 MA4/D outp 0.04597f
C2 S1/D S4/G 0.38004f
C3 MA3/G outn 0.13259f
C4 S4/D MB4/D 0.07938f
C5 clk VDD 0.35949f
C6 inn M7/D 0.16657f
C7 MB3/G MB4/D 0.02119f
C8 clk S1/D 0.07037f
C9 MB4/D outp 0.02306f
C10 MA4/D MA3/G 0.26498f
C11 S4/D M7/D 0.03993f
C12 clk S4/G 0.34475f
C13 S3/D S4/D 0.95325f
C14 S2/D M7/D 0.48736f
C15 inn S2/D 0.15553f
C16 S3/D S2/D 0.10932f
C17 S3/D MB3/G 0.65303f
C18 S3/D outp 0.12342f
C19 MA3/G MB4/D 0.13289f
C20 S4/D S2/D 0.16122f
C21 S4/D MB3/G 0.15634f
C22 VDD M7/D 0.69771f
C23 inn VDD 0.1829f
C24 outn MB4/D 0.11992f
C25 S3/D VDD 0.48735f
C26 S2/D MB3/G 0.04781f
C27 S4/D outp 0.25666f
C28 inp M7/D 0.17391f
C29 inp inn 0.01243f
C30 S1/D M7/D 0.42559f
C31 MB3/G outp 0.44333f
C32 S3/D S1/D 0.24377f
C33 S4/D VDD 0.75506f
C34 S3/D MA3/G 0.01873f
C35 S4/G M7/D 0.56637f
C36 S2/D VDD 0.5264f
C37 MB3/G VDD 0.87835f
C38 S4/D S1/D 0.10241f
C39 S3/D S4/G 0.45578f
C40 VDD outp 0.55706f
C41 S1/D S2/D 0.05161f
C42 MA3/G S4/D 0.82168f
C43 S4/D outn 0.06664f
C44 S4/D S4/G 0.6753f
C45 MA3/G MB3/G 0.13325f
C46 outn MB3/G 0.24626f
C47 S2/D S4/G 0.17409f
C48 MA3/G outp 0.18297f
C49 inp VDD 0.05141f
C50 S1/D VDD 0.32194f
C51 outn outp 0.32505f
C52 inp S1/D 0.17491f
C53 MA3/G VDD 1.08574f
C54 MA4/D S4/D 0.03863f
C55 outn VDD 0.68169f
C56 S4/G VDD 0.62515f
C57 clk VSS 0.19819f
C58 outn VSS 0.10941f
C59 S4/D VSS 1.13633f
C60 MA4/D VSS 0.06458f
C61 MB4/D VSS 0.24804f
C62 outp VSS 0.06057f
C63 MA3/G VSS 0.95602f
C64 VDD VSS -0.43421f
C65 S3/D VSS 1.16086f
C66 S2/D VSS 0.58021f
C67 inn VSS -0.0295f
C68 S4/G VSS 1.44195f
C69 M7/D VSS -0.91245f
C70 inp VSS -0.03034f
C71 MB3/G VSS 0.4016f
C72 S1/D VSS 0.55544f
.ends

.subckt adc_core phi clk vin comp dn7 VDD dn6 dn5 VSS dn4 dn3 dn2 dn1 Vref dn0
Xbootstrap_switch_0 phi vin cdac_0/vtop bootstrap_switch_0/M9/G bootstrap_switch_0/M9/D
+ bootstrap_switch_0/MIP/D bootstrap_switch_0/M8/G bootstrap_switch_0/M8/S VDD VSS
+ bootstrap_switch
Xcdac_0 dn2 dn5 dn6 dn7 cdac_0/vtop VDD dn4 cdac_0/MP7/D6
+ cdac_0/MN5/D dn1 dn3 cdac_0/MP6/D2 Vref dn0 VSS cdac
Xdecap_0 Vref VSS decap
Xvcm_gen_0 vcm_gen_0/vcm Vref VSS vcm_gen
Xcomparator_0 cdac_0/vtop vcm_gen_0/vcm clk comp comparator_0/outn comparator_0/MB3/G
+ comparator_0/S2/D comparator_0/S4/D comparator_0/MA3/G comparator_0/S4/G VDD comparator_0/S1/D
+ VSS comparator_0/M7/D comparator
C0 sar_logic_0/w_514_527# VDD 0.84651f
C1 uo_out[5] uo_out[7] 0.26192f
C2 phi bootstrap_switch_0/M8/G 0.25191f
C3 cdac_0/MP7/D6 comparator_0/MA3/G 0.01672f
C4 phi bootstrap_switch_0/M9/D 1.35823f
C5 uo_out[0] uo_out[5] 0.12146f
C6 uo_out[2] clk 0.05433f
C7 uo_out[6] uo_out[7] 0.54937f
C8 uo_out[3] uo_out[5] 0.12194f
C9 cdac_0/MP7/D6 Vref 0.36674f
C10 VDD bootstrap_switch_0/MIP/D 0.14048f
C11 uo_out[3] uo_out[6] 0.10306f
C12 Vref cdac_0/MN5/D 0.09576f
C13 dn5 dn6 0.23758f
C14 Vref bootstrap_switch_0/M9/D 0.16766f
C15 uo_out[2] uo_out[4] 0.05594f
C16 dn2 dn1 0.1132f
C17 dn2 Vref 0.02661f
C18 comp cdac_0/vtop 0.05655f
C19 phi cdac_0/vtop 0.19328f
C20 ui_in[4] ui_in[5] 0.01551f
C21 comp VDD 0.38871f
C22 phi VDD 0.04589f
C23 Vref dn6 0.03496f
C24 uio_in[3] uio_in[4] 0.01551f
C25 uo_out[0] uo_out[1] 0.26901f
C26 uo_out[6] uo_out[5] 0.13097f
C27 uio_in[4] uio_in[5] 0.01551f
C28 ui_in[0] rst_n 0.0205f
C29 comparator_0/MA3/G cdac_0/vtop 0.04838f
C30 vcm_gen_0/vcm clk 0.057f
C31 vcm_gen_0/vcm cdac_0/vtop 0.34126f
C32 comparator_0/MA3/G VDD 0.01238f
C33 vcm_gen_0/vcm VDD 0.34013f
C34 uo_out[3] uo_out[1] 0.93265f
C35 comp dn7 0.01216f
C36 Vref cdac_0/vtop 3.46748f
C37 comparator_0/MB3/G VDD -0.01202f
C38 Vref VDD 5.59282f
C39 uo_out[5] uo_out[1] 0.12225f
C40 clk uo_out[7] 0.0802f
C41 vcm_gen_0/vcm comparator_0/S4/G 0.04859f
C42 ena clk 0.01632f
C43 uo_out[6] uo_out[1] 0.10046f
C44 comparator_0/S2/D cdac_0/vtop 0.02312f
C45 uo_out[0] clk 0.11845f
C46 dn7 Vref 0.01899f
C47 dn2 dn3 0.08755f
C48 uio_out[0] uo_out[7] 0.41649f
C49 ui_in[6] ui_in[7] 0.01551f
C50 phi bootstrap_switch_0/M8/S 0.04784f
C51 ui_in[3] ui_in[4] 0.01551f
C52 uo_out[3] clk 0.15048f
C53 uo_out[4] uo_out[7] 0.10998f
C54 comparator_0/M7/D clk 0.01716f
C55 uo_out[0] uo_out[4] 0.43462f
C56 bootstrap_switch_0/M9/G cdac_0/vtop 0.02901f
C57 comparator_0/M7/D cdac_0/vtop 0.27038f
C58 uio_in[5] uio_in[6] 0.01551f
C59 Vref cdac_0/MP6/D2 0.07673f
C60 uo_out[5] clk 0.05426f
C61 Vref bootstrap_switch_0/M8/S 0.08093f
C62 comparator_0/M7/D VDD -0.02996f
C63 uo_out[3] uo_out[4] 0.98134f
C64 uio_out[0] uo_out[5] 0.04221f
C65 uo_out[6] clk 0.11045f
C66 uo_out[0] rst_n 0.02634f
C67 uio_out[0] uo_out[6] 0.12684f
C68 dn4 dn5 0.08035f
C69 VDD comparator_0/S4/D 0.04646f
C70 uo_out[5] uo_out[4] 0.18088f
C71 phi dn0 0.01033f
C72 Vref bootstrap_switch_0/MIP/D 0.07534f
C73 vin cdac_0/vtop 0.01463f
C74 comp comparator_0/MA3/G 0.06916f
C75 uo_out[6] uo_out[4] 0.49934f
C76 uio_in[1] uio_in[0] 0.01551f
C77 dn4 Vref 0.02221f
C78 clk uo_out[1] 0.86267f
C79 comp comparator_0/MB3/G 0.05193f
C80 cdac_0/MP7/D6 VDD 0.37562f
C81 uo_out[0] uo_out[2] 1.05758f
C82 phi Vref 0.24509f
C83 ui_in[6] ui_in[5] 0.01551f
C84 bootstrap_switch_0/M9/D cdac_0/vtop 0.31696f
C85 dn0 dn1 0.01125f
C86 Vref dn0 0.2583f
C87 bootstrap_switch_0/M8/G VDD -0.01657f
C88 uo_out[3] uo_out[2] 0.07307f
C89 Vref vcm_gen_0/vcm 0.11235f
C90 uo_out[4] uo_out[1] 0.10491f
C91 Vref dn5 0.0305f
C92 VDD dn6 0.24255f
C93 Vref dn1 0.02501f
C94 ui_in[3] ui_in[2] 0.01551f
C95 uio_in[7] uo_out[0] 0.01668f
C96 uo_out[2] uo_out[5] 0.52873f
C97 dn7 dn6 0.0198f
C98 uo_out[2] uo_out[6] 0.15632f
C99 VDD clk 0.14112f
C100 VDD cdac_0/vtop 1.16246f
C101 uio_out[0] clk 0.07761f
C102 dn4 dn3 0.10807f
C103 phi bootstrap_switch_0/M9/G 0.01142f
C104 uio_in[7] uio_in[6] 0.01551f
C105 bootstrap_switch_0/M8/G bootstrap_switch_0/M8/S -0.02062f
C106 uo_out[4] clk 0.0902f
C107 uio_in[0] ui_in[7] 0.01551f
C108 comparator_0/M7/D vcm_gen_0/vcm 0.16279f
C109 dn7 VDD 0.17386f
C110 comparator_0/S4/G clk 0.02935f
C111 comparator_0/S4/G cdac_0/vtop 0.04862f
C112 uo_out[2] uo_out[1] 0.17656f
C113 rst_n clk 0.16605f
C114 comparator_0/S1/D clk 0.01879f
C115 comparator_0/S1/D cdac_0/vtop 0.01439f
C116 ui_in[1] ui_in[2] 0.01551f
C117 Vref dn3 0.04897f
C118 uio_in[2] uio_in[1] 0.01551f
C119 uo_out[3] uo_out[7] 0.06405f
C120 uo_out[3] uo_out[0] 0.14217f
C121 bootstrap_switch_0/M8/S cdac_0/vtop 0.0381f
C122 uio_in[3] uio_in[2] 0.01551f
C123 ui_in[0] ui_in[1] 0.01551f
C124 phi cdac_0/MP7/D6 0.09707f
C125 ua[2] VSS 0.14709f
C126 ua[3] VSS 0.14709f
C127 ua[4] VSS 0.14696f
C128 ua[5] VSS 0.14696f
C129 ua[6] VSS 0.14696f
C130 ua[7] VSS 0.14696f
C131 ena VSS 0.06988f
C132 ui_in[0] VSS 0.04185f
C133 ui_in[1] VSS 0.04236f
C134 ui_in[2] VSS 0.0427f
C135 ui_in[3] VSS 0.0427f
C136 ui_in[4] VSS 0.04219f
C137 ui_in[5] VSS 0.0424f
C138 ui_in[6] VSS 0.04232f
C139 ui_in[7] VSS 0.04219f
C140 uio_in[0] VSS 0.04219f
C141 uio_in[1] VSS 0.04186f
C142 uio_in[2] VSS 0.04186f
C143 uio_in[3] VSS 0.04162f
C144 uio_in[4] VSS 0.04162f
C145 uio_in[5] VSS 0.04135f
C146 uio_in[6] VSS 0.04135f
C147 uio_in[7] VSS 0.04049f
C148 clk VSS 13.22126f
C149 comparator_0/outn VSS -0.62408f
C150 comparator_0/S4/D VSS -0.77582f
C151 comparator_0/MA4/D VSS -0.2041f
C152 comparator_0/MB4/D VSS -0.20036f
C153 comp VSS 1.98711f
C154 comparator_0/MA3/G VSS -0.33594f
C155 VDD VSS 34.20207f
C156 comparator_0/S3/D VSS -0.93371f
C157 comparator_0/S2/D VSS -0.58538f
C158 comparator_0/S4/G VSS -0.98275f
C159 comparator_0/M7/D VSS -1.71856f
C160 cdac_0/vtop VSS 1.75228f
C161 comparator_0/MB3/G VSS -0.56487f
C162 comparator_0/S1/D VSS -0.625f
C163 vcm_gen_0/vcm VSS 6.92344f
C164 rst_n VSS 1.11353f
C165 uo_out[0] VSS 1.05978f
C166 uo_out[1] VSS 0.33606f
C167 uo_out[2] VSS 0.84949f
C168 uo_out[3] VSS 0.32164f
C169 uo_out[4] VSS 0.36492f
C170 uo_out[5] VSS 1.01208f
C171 uo_out[6] VSS 0.48843f
C172 uo_out[7] VSS 0.62577f
C173 uio_out[0] VSS 1.01276f
C174 sar_logic_0/w_514_527# VSS 0.84651f ; **FLOATING
C175 Vref VSS -11.92775f
C176 dn5 VSS 0.91388f
C177 dn0 VSS 1.45735f
C178 dn1 VSS 1.18497f
C179 dn2 VSS 0.61165f
C180 dn3 VSS 0.65256f
C181 dn4 VSS 0.76961f
C182 cdac_0/MP7/D6 VSS -2.7868f
C183 dn7 VSS 0.58818f
C184 cdac_0/MP6/D2 VSS -1.43685f
C185 dn6 VSS 1.15708f
C186 cdac_0/MN5/D VSS -0.42942f
C187 cdac_0/MP4/D VSS -0.25287f
C188 cdac_0/MP3/D VSS -0.12906f
C189 cdac_0/MP2/D VSS -0.12793f
C190 cdac_0/MP1/D VSS -0.12955f
C191 cdac_0/MP0/D VSS -0.12208f
C192 vin VSS 0.69999f
C193 bootstrap_switch_0/M8/S VSS -1.8174f
C194 bootstrap_switch_0/MIP/D VSS -0.19926f
C195 phi VSS 1.4888f
C196 bootstrap_switch_0/M8/G VSS -0.39672f
C197 bootstrap_switch_0/M9/D VSS -1.44712f
C198 bootstrap_switch_0/M14/S VSS -0.15663f
C199 bootstrap_switch_0/M9/G VSS -0.58755f
Rtie0 bootstrap_switch_0/M14/S VSS 1G
Rtie1 bootstrap_switch_0/M9/D VSS 1G
Rtie2 cdac_0/MP0/D VSS 1G
Rtie3 cdac_0/MP1/D VSS 1G
Rtie4 cdac_0/MP2/D VSS 1G
Rtie5 cdac_0/MP3/D VSS 1G
Rtie6 cdac_0/MP4/D VSS 1G
Rtie7 cdac_0/MP7/D6 VSS 1G
Rtie8 comparator_0/MA4/D VSS 1G
Rtie9 comparator_0/MB3/G VSS 1G
Rtie10 comparator_0/MB4/D VSS 1G
Rtie11 comparator_0/S3/D VSS 1G
Rtie12 ena VSS 1G
Rtie13 rst_n VSS 1G
Rtie14 sar_logic_0/w_514_527# VSS 1G
Rtie15 ua[2] VSS 1G
Rtie16 ua[3] VSS 1G
Rtie17 ua[4] VSS 1G
Rtie18 ua[5] VSS 1G
Rtie19 ua[6] VSS 1G
Rtie20 ua[7] VSS 1G
Rtie21 ui_in[0] VSS 1G
Rtie22 ui_in[1] VSS 1G
Rtie23 ui_in[2] VSS 1G
Rtie24 ui_in[3] VSS 1G
Rtie25 ui_in[4] VSS 1G
Rtie26 ui_in[5] VSS 1G
Rtie27 ui_in[6] VSS 1G
Rtie28 ui_in[7] VSS 1G
Rtie29 uio_in[0] VSS 1G
Rtie30 uio_in[1] VSS 1G
Rtie31 uio_in[2] VSS 1G
Rtie32 uio_in[3] VSS 1G
Rtie33 uio_in[4] VSS 1G
Rtie34 uio_in[5] VSS 1G
Rtie35 uio_in[6] VSS 1G
Rtie36 uio_in[7] VSS 1G
Rtie37 uio_out[0] VSS 1G
Rtie38 uo_out[0] VSS 1G
Rtie39 uo_out[1] VSS 1G
Rtie40 uo_out[2] VSS 1G
Rtie41 uo_out[3] VSS 1G
Rtie42 uo_out[4] VSS 1G
Rtie43 uo_out[5] VSS 1G
Rtie44 uo_out[6] VSS 1G
Rtie45 uo_out[7] VSS 1G
.ends
