* adc_mixed.cir -- full 8-bit SAR ADC, first functional co-simulation
*   analog core : ../xschem/simulation/adc_core.spice  (xschem LVS-style netlist of adc_core.sch)
*   SAR logic   : ../verilog/rtl/sar_logic.v  via Verilator (ngspice vlnggen) + XSPICE d_cosim
* Run from this folder (sim/):
*   ngspice vlnggen ../verilog/rtl/sar_logic.v        (rebuild every time the Verilog changes)
*   grep "^\.subckt adc_core" ../xschem/simulation/adc_core.spice | sed 's/^\.subckt adc_core/xcore/; s/$/ adc_core/' > xcore.inc
*   ngspice -b adc_mixed.cir 2>&1 | grep -iE "^vin|rror"
.lib /foss/pdks/sky130A/libs.tech/combined/sky130.lib.spice tt
.include ../xschem/simulation/adc_core.spice
* xcore.inc = one line "xcore <pins in .subckt order> adc_core"; every net has the same name as its pin
.include xcore.inc

* ---- supplies and the two Tiny Tapeout analog pins (500 ohm path each) ----
vvdd VDD 0 1.8
vvss VSS 0 0
vrefx vrefx 0 dc 1.0
rref vrefx Vref 500
vinx vinx 0 dc 0.6
rin vinx vin 500

* ---- clock (10 MHz, rises at 50 ns) and reset (released at 120 ns, between edges) ----
vclk clk 0 pulse 0 1.8 50n 0.1n 0.1n 49.8n 100n
vrst rst_n 0 pwl 0 0 120n 0 120.1n 1.8

* ---- analog -> digital ----
abin [clk rst_n comp] [clk_d rst_d comp_d] adcb
.model adcb adc_bridge(in_low=0.85 in_high=0.95)

* ---- the Verilog SAR logic; ports in module order: inputs [clk rst_n comp],
*      outputs [phi dn[7:0] code[7:0] done], vectors MSB first ----
adut [clk_d rst_d comp_d] [phi_d dn7_d dn6_d dn5_d dn4_d dn3_d dn2_d dn1_d dn0_d c7_d c6_d c5_d c4_d c3_d c2_d c1_d c0_d done_d] null dut
.model dut d_cosim simulation="./sar_logic.so"

* ---- digital -> analog (1.8 V logic) ----
about [phi_d dn7_d dn6_d dn5_d dn4_d dn3_d dn2_d dn1_d dn0_d c7_d c6_d c5_d c4_d c3_d c2_d c1_d c0_d done_d] [phi dn7 dn6 dn5 dn4 dn3 dn2 dn1 dn0 c7 c6 c5 c4 c3 c2 c1 c0 done] dacb
.model dacb dac_bridge(out_low=0 out_high=1.8 out_undef=0.9 input_load=1e-12 t_rise=0.2n t_fall=0.2n)

* ---- 6 input values; ideal codes (Vref=1.0, LSB=3.906 mV): 25, 76, 128, 153, 179, 230 ----
* first conversion: sample 0-200 ns (power-up); second conversion done at ~2.1 us -> read code at 2.15 us
.control
foreach v 0.1 0.3 0.502 0.6 0.7 0.9
  alter vinx dc = $v
  tran 0.1n 2.2u
  meas tran b7 find v(c7) at=2.15u
  meas tran b6 find v(c6) at=2.15u
  meas tran b5 find v(c5) at=2.15u
  meas tran b4 find v(c4) at=2.15u
  meas tran b3 find v(c3) at=2.15u
  meas tran b2 find v(c2) at=2.15u
  meas tran b1 find v(c1) at=2.15u
  meas tran b0 find v(c0) at=2.15u
  let code = (b7 gt 0.9)*128 + (b6 gt 0.9)*64 + (b5 gt 0.9)*32 + (b4 gt 0.9)*16 + (b3 gt 0.9)*8 + (b2 gt 0.9)*4 + (b1 gt 0.9)*2 + (b0 gt 0.9)
  echo vin $v code $&code
  destroy all
end
.endc
.end
