.subckt sar_logic VGND VPWR clk code[0] code[1] code[2] code[3] code[4] code[5] code[6] code[7] comp dn[0] dn[1] dn[2] dn[3] dn[4] dn[5] dn[6] dn[7] done phi rst_n
XFILLER_0_135 VGND VGND VPWR VPWR sky130_fd_sc_hd__fill_2
XFILLER_0_15 VGND VGND VPWR VPWR sky130_fd_sc_hd__fill_1
XFILLER_0_29 VGND VGND VPWR VPWR sky130_fd_sc_hd__decap_4
XFILLER_0_55 VGND VGND VPWR VPWR sky130_fd_sc_hd__fill_1
XFILLER_0_57 VGND VGND VPWR VPWR sky130_fd_sc_hd__decap_4
XFILLER_0_61 VGND VGND VPWR VPWR sky130_fd_sc_hd__fill_1
XFILLER_0_7 VGND VGND VPWR VPWR sky130_fd_sc_hd__decap_8
XFILLER_0_85 VGND VGND VPWR VPWR sky130_fd_sc_hd__decap_4
XFILLER_0_89 VGND VGND VPWR VPWR sky130_fd_sc_hd__fill_1
XFILLER_10_127 VGND VGND VPWR VPWR sky130_fd_sc_hd__decap_8
XFILLER_10_135 VGND VGND VPWR VPWR sky130_fd_sc_hd__fill_2
XFILLER_10_15 VGND VGND VPWR VPWR sky130_fd_sc_hd__decap_4
XFILLER_10_19 VGND VGND VPWR VPWR sky130_fd_sc_hd__fill_1
XFILLER_10_29 VGND VGND VPWR VPWR sky130_fd_sc_hd__fill_1
XFILLER_10_3 VGND VGND VPWR VPWR sky130_ef_sc_hd__decap_12
XFILLER_10_43 VGND VGND VPWR VPWR sky130_fd_sc_hd__decap_3
XFILLER_10_54 VGND VGND VPWR VPWR sky130_fd_sc_hd__fill_1
XFILLER_10_65 VGND VGND VPWR VPWR sky130_ef_sc_hd__decap_12
XFILLER_11_129 VGND VGND VPWR VPWR sky130_fd_sc_hd__decap_8
XFILLER_11_15 VGND VGND VPWR VPWR sky130_fd_sc_hd__decap_8
XFILLER_11_23 VGND VGND VPWR VPWR sky130_fd_sc_hd__fill_1
XFILLER_11_3 VGND VGND VPWR VPWR sky130_ef_sc_hd__decap_12
XFILLER_11_39 VGND VGND VPWR VPWR sky130_fd_sc_hd__fill_1
XFILLER_11_47 VGND VGND VPWR VPWR sky130_fd_sc_hd__decap_8
XFILLER_11_55 VGND VGND VPWR VPWR sky130_fd_sc_hd__fill_1
XFILLER_11_57 VGND VGND VPWR VPWR sky130_ef_sc_hd__decap_12
XFILLER_11_69 VGND VGND VPWR VPWR sky130_fd_sc_hd__fill_1
XFILLER_11_98 VGND VGND VPWR VPWR sky130_fd_sc_hd__decap_8
XFILLER_12_108 VGND VGND VPWR VPWR sky130_fd_sc_hd__decap_8
XFILLER_12_116 VGND VGND VPWR VPWR sky130_fd_sc_hd__fill_2
XFILLER_12_126 VGND VGND VPWR VPWR sky130_fd_sc_hd__decap_8
XFILLER_12_134 VGND VGND VPWR VPWR sky130_fd_sc_hd__decap_3
XFILLER_12_15 VGND VGND VPWR VPWR sky130_fd_sc_hd__decap_8
XFILLER_12_23 VGND VGND VPWR VPWR sky130_fd_sc_hd__fill_2
XFILLER_12_29 VGND VGND VPWR VPWR sky130_fd_sc_hd__fill_2
XFILLER_12_3 VGND VGND VPWR VPWR sky130_ef_sc_hd__decap_12
XFILLER_12_54 VGND VGND VPWR VPWR sky130_fd_sc_hd__fill_1
XFILLER_12_59 VGND VGND VPWR VPWR sky130_fd_sc_hd__fill_2
XFILLER_12_81 VGND VGND VPWR VPWR sky130_fd_sc_hd__decap_3
XFILLER_12_96 VGND VGND VPWR VPWR sky130_ef_sc_hd__decap_12
XFILLER_13_107 VGND VGND VPWR VPWR sky130_fd_sc_hd__decap_4
XFILLER_13_111 VGND VGND VPWR VPWR sky130_fd_sc_hd__fill_1
XFILLER_13_113 VGND VGND VPWR VPWR sky130_ef_sc_hd__decap_12
XFILLER_13_125 VGND VGND VPWR VPWR sky130_ef_sc_hd__decap_12
XFILLER_13_3 VGND VGND VPWR VPWR sky130_ef_sc_hd__decap_12
XFILLER_13_65 VGND VGND VPWR VPWR sky130_fd_sc_hd__decap_6
XFILLER_14_120 VGND VGND VPWR VPWR sky130_ef_sc_hd__decap_12
XFILLER_14_132 VGND VGND VPWR VPWR sky130_fd_sc_hd__decap_4
XFILLER_14_136 VGND VGND VPWR VPWR sky130_fd_sc_hd__fill_1
XFILLER_14_15 VGND VGND VPWR VPWR sky130_ef_sc_hd__decap_12
XFILLER_14_27 VGND VGND VPWR VPWR sky130_fd_sc_hd__fill_1
XFILLER_14_3 VGND VGND VPWR VPWR sky130_ef_sc_hd__decap_12
XFILLER_14_50 VGND VGND VPWR VPWR sky130_fd_sc_hd__fill_1
XFILLER_14_65 VGND VGND VPWR VPWR sky130_fd_sc_hd__decap_3
XFILLER_14_83 VGND VGND VPWR VPWR sky130_fd_sc_hd__fill_1
XFILLER_14_85 VGND VGND VPWR VPWR sky130_fd_sc_hd__decap_4
XFILLER_14_94 VGND VGND VPWR VPWR sky130_fd_sc_hd__fill_2
XFILLER_15_101 VGND VGND VPWR VPWR sky130_fd_sc_hd__decap_8
XFILLER_15_109 VGND VGND VPWR VPWR sky130_fd_sc_hd__decap_3
XFILLER_15_113 VGND VGND VPWR VPWR sky130_ef_sc_hd__decap_12
XFILLER_15_125 VGND VGND VPWR VPWR sky130_ef_sc_hd__decap_12
XFILLER_15_15 VGND VGND VPWR VPWR sky130_fd_sc_hd__decap_4
XFILLER_15_19 VGND VGND VPWR VPWR sky130_fd_sc_hd__fill_1
XFILLER_15_3 VGND VGND VPWR VPWR sky130_ef_sc_hd__decap_12
XFILLER_15_35 VGND VGND VPWR VPWR sky130_fd_sc_hd__fill_2
XFILLER_15_44 VGND VGND VPWR VPWR sky130_fd_sc_hd__fill_2
XFILLER_15_54 VGND VGND VPWR VPWR sky130_fd_sc_hd__fill_2
XFILLER_15_85 VGND VGND VPWR VPWR sky130_fd_sc_hd__decap_4
XFILLER_16_108 VGND VGND VPWR VPWR sky130_ef_sc_hd__decap_12
XFILLER_16_120 VGND VGND VPWR VPWR sky130_ef_sc_hd__decap_12
XFILLER_16_132 VGND VGND VPWR VPWR sky130_fd_sc_hd__decap_4
XFILLER_16_136 VGND VGND VPWR VPWR sky130_fd_sc_hd__fill_1
XFILLER_16_15 VGND VGND VPWR VPWR sky130_fd_sc_hd__decap_3
XFILLER_16_29 VGND VGND VPWR VPWR sky130_fd_sc_hd__fill_2
XFILLER_16_3 VGND VGND VPWR VPWR sky130_ef_sc_hd__decap_12
XFILLER_16_54 VGND VGND VPWR VPWR sky130_ef_sc_hd__decap_12
XFILLER_16_66 VGND VGND VPWR VPWR sky130_fd_sc_hd__fill_2
XFILLER_16_72 VGND VGND VPWR VPWR sky130_fd_sc_hd__decap_8
XFILLER_17_11 VGND VGND VPWR VPWR sky130_fd_sc_hd__fill_2
XFILLER_17_110 VGND VGND VPWR VPWR sky130_fd_sc_hd__fill_2
XFILLER_17_113 VGND VGND VPWR VPWR sky130_ef_sc_hd__decap_12
XFILLER_17_125 VGND VGND VPWR VPWR sky130_ef_sc_hd__decap_12
XFILLER_17_3 VGND VGND VPWR VPWR sky130_fd_sc_hd__decap_8
XFILLER_17_55 VGND VGND VPWR VPWR sky130_fd_sc_hd__fill_1
XFILLER_17_63 VGND VGND VPWR VPWR sky130_fd_sc_hd__decap_3
XFILLER_17_83 VGND VGND VPWR VPWR sky130_fd_sc_hd__fill_2
XFILLER_17_93 VGND VGND VPWR VPWR sky130_fd_sc_hd__decap_3
XFILLER_18_11 VGND VGND VPWR VPWR sky130_fd_sc_hd__fill_1
XFILLER_18_113 VGND VGND VPWR VPWR sky130_ef_sc_hd__decap_12
XFILLER_18_125 VGND VGND VPWR VPWR sky130_ef_sc_hd__decap_12
XFILLER_18_3 VGND VGND VPWR VPWR sky130_fd_sc_hd__decap_8
XFILLER_19_11 VGND VGND VPWR VPWR sky130_fd_sc_hd__fill_2
XFILLER_19_111 VGND VGND VPWR VPWR sky130_fd_sc_hd__fill_1
XFILLER_19_113 VGND VGND VPWR VPWR sky130_ef_sc_hd__decap_12
XFILLER_19_125 VGND VGND VPWR VPWR sky130_ef_sc_hd__decap_12
XFILLER_19_3 VGND VGND VPWR VPWR sky130_fd_sc_hd__fill_2
XFILLER_19_53 VGND VGND VPWR VPWR sky130_fd_sc_hd__decap_3
XFILLER_19_57 VGND VGND VPWR VPWR sky130_fd_sc_hd__fill_2
XFILLER_1_100 VGND VGND VPWR VPWR sky130_fd_sc_hd__decap_6
XFILLER_1_113 VGND VGND VPWR VPWR sky130_fd_sc_hd__fill_2
XFILLER_1_15 VGND VGND VPWR VPWR sky130_fd_sc_hd__decap_3
XFILLER_1_3 VGND VGND VPWR VPWR sky130_ef_sc_hd__decap_12
XFILLER_1_69 VGND VGND VPWR VPWR sky130_fd_sc_hd__decap_3
XFILLER_20_118 VGND VGND VPWR VPWR sky130_fd_sc_hd__decap_3
XFILLER_20_127 VGND VGND VPWR VPWR sky130_fd_sc_hd__decap_8
XFILLER_20_135 VGND VGND VPWR VPWR sky130_fd_sc_hd__fill_2
XFILLER_20_3 VGND VGND VPWR VPWR sky130_fd_sc_hd__decap_4
XFILLER_20_7 VGND VGND VPWR VPWR sky130_fd_sc_hd__fill_1
XFILLER_20_85 VGND VGND VPWR VPWR sky130_fd_sc_hd__fill_2
XFILLER_21_133 VGND VGND VPWR VPWR sky130_fd_sc_hd__decap_4
XFILLER_21_27 VGND VGND VPWR VPWR sky130_fd_sc_hd__decap_4
XFILLER_21_3 VGND VGND VPWR VPWR sky130_fd_sc_hd__fill_2
XFILLER_21_53 VGND VGND VPWR VPWR sky130_fd_sc_hd__decap_3
XFILLER_21_57 VGND VGND VPWR VPWR sky130_fd_sc_hd__fill_1
XFILLER_22_107 VGND VGND VPWR VPWR sky130_fd_sc_hd__decap_4
XFILLER_22_111 VGND VGND VPWR VPWR sky130_fd_sc_hd__fill_1
XFILLER_22_135 VGND VGND VPWR VPWR sky130_fd_sc_hd__fill_2
XFILLER_22_29 VGND VGND VPWR VPWR sky130_fd_sc_hd__decap_4
XFILLER_22_3 VGND VGND VPWR VPWR sky130_fd_sc_hd__decap_3
XFILLER_22_33 VGND VGND VPWR VPWR sky130_fd_sc_hd__fill_1
XFILLER_22_79 VGND VGND VPWR VPWR sky130_fd_sc_hd__decap_4
XFILLER_22_83 VGND VGND VPWR VPWR sky130_fd_sc_hd__fill_1
XFILLER_2_107 VGND VGND VPWR VPWR sky130_fd_sc_hd__decap_8
XFILLER_2_15 VGND VGND VPWR VPWR sky130_ef_sc_hd__decap_12
XFILLER_2_27 VGND VGND VPWR VPWR sky130_fd_sc_hd__fill_1
XFILLER_2_29 VGND VGND VPWR VPWR sky130_fd_sc_hd__decap_3
XFILLER_2_3 VGND VGND VPWR VPWR sky130_ef_sc_hd__decap_12
XFILLER_2_70 VGND VGND VPWR VPWR sky130_fd_sc_hd__decap_4
XFILLER_2_82 VGND VGND VPWR VPWR sky130_fd_sc_hd__fill_2
XFILLER_3_104 VGND VGND VPWR VPWR sky130_fd_sc_hd__decap_8
XFILLER_3_113 VGND VGND VPWR VPWR sky130_fd_sc_hd__decap_8
XFILLER_3_121 VGND VGND VPWR VPWR sky130_fd_sc_hd__fill_2
XFILLER_3_129 VGND VGND VPWR VPWR sky130_fd_sc_hd__fill_2
XFILLER_3_15 VGND VGND VPWR VPWR sky130_fd_sc_hd__decap_4
XFILLER_3_3 VGND VGND VPWR VPWR sky130_ef_sc_hd__decap_12
XFILLER_4_105 VGND VGND VPWR VPWR sky130_ef_sc_hd__decap_12
XFILLER_4_117 VGND VGND VPWR VPWR sky130_ef_sc_hd__decap_12
XFILLER_4_129 VGND VGND VPWR VPWR sky130_fd_sc_hd__decap_8
XFILLER_4_15 VGND VGND VPWR VPWR sky130_fd_sc_hd__decap_6
XFILLER_4_21 VGND VGND VPWR VPWR sky130_fd_sc_hd__fill_1
XFILLER_4_3 VGND VGND VPWR VPWR sky130_ef_sc_hd__decap_12
XFILLER_4_32 VGND VGND VPWR VPWR sky130_fd_sc_hd__fill_1
XFILLER_4_62 VGND VGND VPWR VPWR sky130_fd_sc_hd__fill_1
XFILLER_4_66 VGND VGND VPWR VPWR sky130_fd_sc_hd__decap_4
XFILLER_4_83 VGND VGND VPWR VPWR sky130_fd_sc_hd__fill_1
XFILLER_4_88 VGND VGND VPWR VPWR sky130_fd_sc_hd__fill_1
XFILLER_5_104 VGND VGND VPWR VPWR sky130_fd_sc_hd__decap_8
XFILLER_5_113 VGND VGND VPWR VPWR sky130_ef_sc_hd__decap_12
XFILLER_5_125 VGND VGND VPWR VPWR sky130_ef_sc_hd__decap_12
XFILLER_5_15 VGND VGND VPWR VPWR sky130_ef_sc_hd__decap_12
XFILLER_5_27 VGND VGND VPWR VPWR sky130_fd_sc_hd__decap_4
XFILLER_5_3 VGND VGND VPWR VPWR sky130_ef_sc_hd__decap_12
XFILLER_5_55 VGND VGND VPWR VPWR sky130_fd_sc_hd__fill_1
XFILLER_5_63 VGND VGND VPWR VPWR sky130_fd_sc_hd__decap_8
XFILLER_5_84 VGND VGND VPWR VPWR sky130_fd_sc_hd__fill_1
XFILLER_6_113 VGND VGND VPWR VPWR sky130_ef_sc_hd__decap_12
XFILLER_6_125 VGND VGND VPWR VPWR sky130_ef_sc_hd__decap_12
XFILLER_6_15 VGND VGND VPWR VPWR sky130_ef_sc_hd__decap_12
XFILLER_6_27 VGND VGND VPWR VPWR sky130_fd_sc_hd__fill_1
XFILLER_6_29 VGND VGND VPWR VPWR sky130_fd_sc_hd__decap_4
XFILLER_6_3 VGND VGND VPWR VPWR sky130_ef_sc_hd__decap_12
XFILLER_6_33 VGND VGND VPWR VPWR sky130_fd_sc_hd__fill_1
XFILLER_6_74 VGND VGND VPWR VPWR sky130_fd_sc_hd__fill_2
XFILLER_7_102 VGND VGND VPWR VPWR sky130_fd_sc_hd__decap_8
XFILLER_7_110 VGND VGND VPWR VPWR sky130_fd_sc_hd__fill_2
XFILLER_7_113 VGND VGND VPWR VPWR sky130_ef_sc_hd__decap_12
XFILLER_7_125 VGND VGND VPWR VPWR sky130_ef_sc_hd__decap_12
XFILLER_7_15 VGND VGND VPWR VPWR sky130_fd_sc_hd__fill_2
XFILLER_7_3 VGND VGND VPWR VPWR sky130_ef_sc_hd__decap_12
XFILLER_7_38 VGND VGND VPWR VPWR sky130_fd_sc_hd__decap_3
XFILLER_7_57 VGND VGND VPWR VPWR sky130_fd_sc_hd__decap_4
XFILLER_7_61 VGND VGND VPWR VPWR sky130_fd_sc_hd__fill_1
XFILLER_7_70 VGND VGND VPWR VPWR sky130_fd_sc_hd__decap_4
XFILLER_8_110 VGND VGND VPWR VPWR sky130_ef_sc_hd__decap_12
XFILLER_8_122 VGND VGND VPWR VPWR sky130_ef_sc_hd__decap_12
XFILLER_8_134 VGND VGND VPWR VPWR sky130_fd_sc_hd__decap_3
XFILLER_8_15 VGND VGND VPWR VPWR sky130_fd_sc_hd__fill_2
XFILLER_8_3 VGND VGND VPWR VPWR sky130_ef_sc_hd__decap_12
XFILLER_8_56 VGND VGND VPWR VPWR sky130_fd_sc_hd__decap_8
XFILLER_8_64 VGND VGND VPWR VPWR sky130_fd_sc_hd__decap_3
XFILLER_8_74 VGND VGND VPWR VPWR sky130_fd_sc_hd__decap_6
XFILLER_8_80 VGND VGND VPWR VPWR sky130_fd_sc_hd__fill_1
XFILLER_8_99 VGND VGND VPWR VPWR sky130_fd_sc_hd__decap_8
XFILLER_9_11 VGND VGND VPWR VPWR sky130_fd_sc_hd__decap_3
XFILLER_9_110 VGND VGND VPWR VPWR sky130_fd_sc_hd__fill_2
XFILLER_9_113 VGND VGND VPWR VPWR sky130_ef_sc_hd__decap_12
XFILLER_9_125 VGND VGND VPWR VPWR sky130_ef_sc_hd__decap_12
XFILLER_9_3 VGND VGND VPWR VPWR sky130_fd_sc_hd__decap_8
XFILLER_9_48 VGND VGND VPWR VPWR sky130_fd_sc_hd__decap_8
XFILLER_9_57 VGND VGND VPWR VPWR sky130_ef_sc_hd__decap_12
XFILLER_9_69 VGND VGND VPWR VPWR sky130_fd_sc_hd__decap_8
XPHY_EDGE_ROW_0_Left_23 VGND VGND VPWR VPWR sky130_fd_sc_hd__decap_3
XPHY_EDGE_ROW_0_Right_0 VGND VGND VPWR VPWR sky130_fd_sc_hd__decap_3
XPHY_EDGE_ROW_10_Left_33 VGND VGND VPWR VPWR sky130_fd_sc_hd__decap_3
XPHY_EDGE_ROW_10_Right_10 VGND VGND VPWR VPWR sky130_fd_sc_hd__decap_3
XPHY_EDGE_ROW_11_Left_34 VGND VGND VPWR VPWR sky130_fd_sc_hd__decap_3
XPHY_EDGE_ROW_11_Right_11 VGND VGND VPWR VPWR sky130_fd_sc_hd__decap_3
XPHY_EDGE_ROW_12_Left_35 VGND VGND VPWR VPWR sky130_fd_sc_hd__decap_3
XPHY_EDGE_ROW_12_Right_12 VGND VGND VPWR VPWR sky130_fd_sc_hd__decap_3
XPHY_EDGE_ROW_13_Left_36 VGND VGND VPWR VPWR sky130_fd_sc_hd__decap_3
XPHY_EDGE_ROW_13_Right_13 VGND VGND VPWR VPWR sky130_fd_sc_hd__decap_3
XPHY_EDGE_ROW_14_Left_37 VGND VGND VPWR VPWR sky130_fd_sc_hd__decap_3
XPHY_EDGE_ROW_14_Right_14 VGND VGND VPWR VPWR sky130_fd_sc_hd__decap_3
XPHY_EDGE_ROW_15_Left_38 VGND VGND VPWR VPWR sky130_fd_sc_hd__decap_3
XPHY_EDGE_ROW_15_Right_15 VGND VGND VPWR VPWR sky130_fd_sc_hd__decap_3
XPHY_EDGE_ROW_16_Left_39 VGND VGND VPWR VPWR sky130_fd_sc_hd__decap_3
XPHY_EDGE_ROW_16_Right_16 VGND VGND VPWR VPWR sky130_fd_sc_hd__decap_3
XPHY_EDGE_ROW_17_Left_40 VGND VGND VPWR VPWR sky130_fd_sc_hd__decap_3
XPHY_EDGE_ROW_17_Right_17 VGND VGND VPWR VPWR sky130_fd_sc_hd__decap_3
XPHY_EDGE_ROW_18_Left_41 VGND VGND VPWR VPWR sky130_fd_sc_hd__decap_3
XPHY_EDGE_ROW_18_Right_18 VGND VGND VPWR VPWR sky130_fd_sc_hd__decap_3
XPHY_EDGE_ROW_19_Left_42 VGND VGND VPWR VPWR sky130_fd_sc_hd__decap_3
XPHY_EDGE_ROW_19_Right_19 VGND VGND VPWR VPWR sky130_fd_sc_hd__decap_3
XPHY_EDGE_ROW_1_Left_24 VGND VGND VPWR VPWR sky130_fd_sc_hd__decap_3
XPHY_EDGE_ROW_1_Right_1 VGND VGND VPWR VPWR sky130_fd_sc_hd__decap_3
XPHY_EDGE_ROW_20_Left_43 VGND VGND VPWR VPWR sky130_fd_sc_hd__decap_3
XPHY_EDGE_ROW_20_Right_20 VGND VGND VPWR VPWR sky130_fd_sc_hd__decap_3
XPHY_EDGE_ROW_21_Left_44 VGND VGND VPWR VPWR sky130_fd_sc_hd__decap_3
XPHY_EDGE_ROW_21_Right_21 VGND VGND VPWR VPWR sky130_fd_sc_hd__decap_3
XPHY_EDGE_ROW_22_Left_45 VGND VGND VPWR VPWR sky130_fd_sc_hd__decap_3
XPHY_EDGE_ROW_22_Right_22 VGND VGND VPWR VPWR sky130_fd_sc_hd__decap_3
XPHY_EDGE_ROW_2_Left_25 VGND VGND VPWR VPWR sky130_fd_sc_hd__decap_3
XPHY_EDGE_ROW_2_Right_2 VGND VGND VPWR VPWR sky130_fd_sc_hd__decap_3
XPHY_EDGE_ROW_3_Left_26 VGND VGND VPWR VPWR sky130_fd_sc_hd__decap_3
XPHY_EDGE_ROW_3_Right_3 VGND VGND VPWR VPWR sky130_fd_sc_hd__decap_3
XPHY_EDGE_ROW_4_Left_27 VGND VGND VPWR VPWR sky130_fd_sc_hd__decap_3
XPHY_EDGE_ROW_4_Right_4 VGND VGND VPWR VPWR sky130_fd_sc_hd__decap_3
XPHY_EDGE_ROW_5_Left_28 VGND VGND VPWR VPWR sky130_fd_sc_hd__decap_3
XPHY_EDGE_ROW_5_Right_5 VGND VGND VPWR VPWR sky130_fd_sc_hd__decap_3
XPHY_EDGE_ROW_6_Left_29 VGND VGND VPWR VPWR sky130_fd_sc_hd__decap_3
XPHY_EDGE_ROW_6_Right_6 VGND VGND VPWR VPWR sky130_fd_sc_hd__decap_3
XPHY_EDGE_ROW_7_Left_30 VGND VGND VPWR VPWR sky130_fd_sc_hd__decap_3
XPHY_EDGE_ROW_7_Right_7 VGND VGND VPWR VPWR sky130_fd_sc_hd__decap_3
XPHY_EDGE_ROW_8_Left_31 VGND VGND VPWR VPWR sky130_fd_sc_hd__decap_3
XPHY_EDGE_ROW_8_Right_8 VGND VGND VPWR VPWR sky130_fd_sc_hd__decap_3
XPHY_EDGE_ROW_9_Left_32 VGND VGND VPWR VPWR sky130_fd_sc_hd__decap_3
XPHY_EDGE_ROW_9_Right_9 VGND VGND VPWR VPWR sky130_fd_sc_hd__decap_3
XTAP_TAPCELL_ROW_0_46 VGND VPWR sky130_fd_sc_hd__tapvpwrvgnd_1
XTAP_TAPCELL_ROW_0_47 VGND VPWR sky130_fd_sc_hd__tapvpwrvgnd_1
XTAP_TAPCELL_ROW_0_48 VGND VPWR sky130_fd_sc_hd__tapvpwrvgnd_1
XTAP_TAPCELL_ROW_0_49 VGND VPWR sky130_fd_sc_hd__tapvpwrvgnd_1
XTAP_TAPCELL_ROW_10_68 VGND VPWR sky130_fd_sc_hd__tapvpwrvgnd_1
XTAP_TAPCELL_ROW_10_69 VGND VPWR sky130_fd_sc_hd__tapvpwrvgnd_1
XTAP_TAPCELL_ROW_11_70 VGND VPWR sky130_fd_sc_hd__tapvpwrvgnd_1
XTAP_TAPCELL_ROW_11_71 VGND VPWR sky130_fd_sc_hd__tapvpwrvgnd_1
XTAP_TAPCELL_ROW_12_72 VGND VPWR sky130_fd_sc_hd__tapvpwrvgnd_1
XTAP_TAPCELL_ROW_12_73 VGND VPWR sky130_fd_sc_hd__tapvpwrvgnd_1
XTAP_TAPCELL_ROW_13_74 VGND VPWR sky130_fd_sc_hd__tapvpwrvgnd_1
XTAP_TAPCELL_ROW_13_75 VGND VPWR sky130_fd_sc_hd__tapvpwrvgnd_1
XTAP_TAPCELL_ROW_14_76 VGND VPWR sky130_fd_sc_hd__tapvpwrvgnd_1
XTAP_TAPCELL_ROW_14_77 VGND VPWR sky130_fd_sc_hd__tapvpwrvgnd_1
XTAP_TAPCELL_ROW_15_78 VGND VPWR sky130_fd_sc_hd__tapvpwrvgnd_1
XTAP_TAPCELL_ROW_15_79 VGND VPWR sky130_fd_sc_hd__tapvpwrvgnd_1
XTAP_TAPCELL_ROW_16_80 VGND VPWR sky130_fd_sc_hd__tapvpwrvgnd_1
XTAP_TAPCELL_ROW_16_81 VGND VPWR sky130_fd_sc_hd__tapvpwrvgnd_1
XTAP_TAPCELL_ROW_17_82 VGND VPWR sky130_fd_sc_hd__tapvpwrvgnd_1
XTAP_TAPCELL_ROW_17_83 VGND VPWR sky130_fd_sc_hd__tapvpwrvgnd_1
XTAP_TAPCELL_ROW_18_84 VGND VPWR sky130_fd_sc_hd__tapvpwrvgnd_1
XTAP_TAPCELL_ROW_18_85 VGND VPWR sky130_fd_sc_hd__tapvpwrvgnd_1
XTAP_TAPCELL_ROW_19_86 VGND VPWR sky130_fd_sc_hd__tapvpwrvgnd_1
XTAP_TAPCELL_ROW_19_87 VGND VPWR sky130_fd_sc_hd__tapvpwrvgnd_1
XTAP_TAPCELL_ROW_1_50 VGND VPWR sky130_fd_sc_hd__tapvpwrvgnd_1
XTAP_TAPCELL_ROW_1_51 VGND VPWR sky130_fd_sc_hd__tapvpwrvgnd_1
XTAP_TAPCELL_ROW_20_88 VGND VPWR sky130_fd_sc_hd__tapvpwrvgnd_1
XTAP_TAPCELL_ROW_20_89 VGND VPWR sky130_fd_sc_hd__tapvpwrvgnd_1
XTAP_TAPCELL_ROW_21_90 VGND VPWR sky130_fd_sc_hd__tapvpwrvgnd_1
XTAP_TAPCELL_ROW_21_91 VGND VPWR sky130_fd_sc_hd__tapvpwrvgnd_1
XTAP_TAPCELL_ROW_22_92 VGND VPWR sky130_fd_sc_hd__tapvpwrvgnd_1
XTAP_TAPCELL_ROW_22_93 VGND VPWR sky130_fd_sc_hd__tapvpwrvgnd_1
XTAP_TAPCELL_ROW_22_94 VGND VPWR sky130_fd_sc_hd__tapvpwrvgnd_1
XTAP_TAPCELL_ROW_22_95 VGND VPWR sky130_fd_sc_hd__tapvpwrvgnd_1
XTAP_TAPCELL_ROW_2_52 VGND VPWR sky130_fd_sc_hd__tapvpwrvgnd_1
XTAP_TAPCELL_ROW_2_53 VGND VPWR sky130_fd_sc_hd__tapvpwrvgnd_1
XTAP_TAPCELL_ROW_3_54 VGND VPWR sky130_fd_sc_hd__tapvpwrvgnd_1
XTAP_TAPCELL_ROW_3_55 VGND VPWR sky130_fd_sc_hd__tapvpwrvgnd_1
XTAP_TAPCELL_ROW_4_56 VGND VPWR sky130_fd_sc_hd__tapvpwrvgnd_1
XTAP_TAPCELL_ROW_4_57 VGND VPWR sky130_fd_sc_hd__tapvpwrvgnd_1
XTAP_TAPCELL_ROW_5_58 VGND VPWR sky130_fd_sc_hd__tapvpwrvgnd_1
XTAP_TAPCELL_ROW_5_59 VGND VPWR sky130_fd_sc_hd__tapvpwrvgnd_1
XTAP_TAPCELL_ROW_6_60 VGND VPWR sky130_fd_sc_hd__tapvpwrvgnd_1
XTAP_TAPCELL_ROW_6_61 VGND VPWR sky130_fd_sc_hd__tapvpwrvgnd_1
XTAP_TAPCELL_ROW_7_62 VGND VPWR sky130_fd_sc_hd__tapvpwrvgnd_1
XTAP_TAPCELL_ROW_7_63 VGND VPWR sky130_fd_sc_hd__tapvpwrvgnd_1
XTAP_TAPCELL_ROW_8_64 VGND VPWR sky130_fd_sc_hd__tapvpwrvgnd_1
XTAP_TAPCELL_ROW_8_65 VGND VPWR sky130_fd_sc_hd__tapvpwrvgnd_1
XTAP_TAPCELL_ROW_9_66 VGND VPWR sky130_fd_sc_hd__tapvpwrvgnd_1
XTAP_TAPCELL_ROW_9_67 VGND VPWR sky130_fd_sc_hd__tapvpwrvgnd_1
X_071_ net48 VGND VGND VPWR VPWR _051_ sky130_fd_sc_hd__inv_1
X_072_ net88 VGND VGND VPWR VPWR _052_ sky130_fd_sc_hd__inv_1
X_073__49 clknet_2_2__leaf_clk VGND VGND VPWR VPWR net49 sky130_fd_sc_hd__inv_1
X_074_ state[1] net41 VGND VGND VPWR VPWR _053_ sky130_fd_sc_hd__or2_0
X_075_ state[1] net41 VGND VGND VPWR VPWR _054_ sky130_fd_sc_hd__nand2b_1
X_076_ net47 sel[6] VGND VGND VPWR VPWR _055_ sky130_fd_sc_hd__and2_0
X_077_ net17 net47 sel[6] VGND VGND VPWR VPWR _056_ sky130_fd_sc_hd__mux2i_1
X_078_ sel[7] sel[6] net17 VGND VGND VPWR VPWR _057_ sky130_fd_sc_hd__nor3b_1
X_079_ _054_ _055_ _057_ _053_ net79 VGND VGND VPWR VPWR _031_ sky130_fd_sc_hd__o32a_1
X_080_ sel[5] sel[6] net16 VGND VGND VPWR VPWR _058_ sky130_fd_sc_hd__nor3b_1
X_081_ net47 sel[5] VGND VGND VPWR VPWR _059_ sky130_fd_sc_hd__and2_0
X_082_ _054_ _058_ _059_ _053_ net77 VGND VGND VPWR VPWR _030_ sky130_fd_sc_hd__o32a_1
X_083_ sel[4] sel[5] net15 VGND VGND VPWR VPWR _060_ sky130_fd_sc_hd__nor3b_1
X_084_ net47 sel[4] VGND VGND VPWR VPWR _061_ sky130_fd_sc_hd__and2_0
X_085_ _054_ _060_ _061_ _053_ net78 VGND VGND VPWR VPWR _029_ sky130_fd_sc_hd__o32a_1
X_086_ sel[3] sel[4] net14 VGND VGND VPWR VPWR _062_ sky130_fd_sc_hd__nor3b_1
X_087_ net47 sel[3] VGND VGND VPWR VPWR _063_ sky130_fd_sc_hd__and2_0
X_088_ _054_ _062_ _063_ _053_ net76 VGND VGND VPWR VPWR _028_ sky130_fd_sc_hd__o32a_1
X_089_ sel[2] sel[3] net13 VGND VGND VPWR VPWR _064_ sky130_fd_sc_hd__nor3b_1
X_090_ net47 sel[2] VGND VGND VPWR VPWR _065_ sky130_fd_sc_hd__and2_0
X_091_ _054_ _064_ _065_ _053_ net75 VGND VGND VPWR VPWR _027_ sky130_fd_sc_hd__o32a_1
X_092_ sel[1] sel[2] net12 VGND VGND VPWR VPWR _066_ sky130_fd_sc_hd__nor3b_1
X_093_ net47 sel[1] VGND VGND VPWR VPWR _067_ sky130_fd_sc_hd__and2_0
X_094_ _054_ _066_ _067_ _053_ net80 VGND VGND VPWR VPWR _026_ sky130_fd_sc_hd__o32a_1
X_095_ state[1] net42 sel[0] sel[1] VGND VGND VPWR VPWR _068_ sky130_fd_sc_hd__o22ai_1
X_096_ net42 sel[0] VGND VGND VPWR VPWR _000_ sky130_fd_sc_hd__and2_0
X_097_ net11 _068_ net30 net48 net58 VGND VGND VPWR VPWR _025_ sky130_fd_sc_hd__a221o_1
X_098_ net73 _052_ net58 VGND VGND VPWR VPWR _024_ sky130_fd_sc_hd__a21o_1
X_099_ sel[0] net42 VGND VGND VPWR VPWR _069_ sky130_fd_sc_hd__nand2b_1
X_100_ _052_ _069_ VGND VGND VPWR VPWR _001_ sky130_fd_sc_hd__nand2_1
X_101_ net15 net47 sel[4] VGND VGND VPWR VPWR _070_ sky130_fd_sc_hd__mux2i_1
X_102_ net42 sel[0] net61 VGND VGND VPWR VPWR _037_ sky130_fd_sc_hd__a21oi_1
X_103_ net30 _070_ _037_ VGND VGND VPWR VPWR _011_ sky130_fd_sc_hd__a21oi_1
X_104_ net16 net47 net92 VGND VGND VPWR VPWR _038_ sky130_fd_sc_hd__mux2i_1
X_105_ net42 sel[0] net62 VGND VGND VPWR VPWR _039_ sky130_fd_sc_hd__a21oi_1
X_106_ net30 _038_ _039_ VGND VGND VPWR VPWR _012_ sky130_fd_sc_hd__a21oi_1
X_107_ net42 sel[0] net66 VGND VGND VPWR VPWR _040_ sky130_fd_sc_hd__a21oi_1
X_108_ _056_ net30 _040_ VGND VGND VPWR VPWR _013_ sky130_fd_sc_hd__a21oi_1
X_109_ net18 net48 sel[7] VGND VGND VPWR VPWR _041_ sky130_fd_sc_hd__mux2_1
X_110_ net63 _041_ net30 VGND VGND VPWR VPWR _014_ sky130_fd_sc_hd__mux2_1
X_111_ net69 net30 _069_ net58 VGND VGND VPWR VPWR _015_ sky130_fd_sc_hd__a2bb2oi_1
X_112_ net41 state[0] VGND VGND VPWR VPWR _042_ sky130_fd_sc_hd__nor2_1
X_113_ net42 net87 net21 sel[0] VGND VGND VPWR VPWR _016_ sky130_fd_sc_hd__a22o_1
X_114_ net41 net84 net21 net87 VGND VGND VPWR VPWR _017_ sky130_fd_sc_hd__a22o_1
X_115_ net41 sel[3] net21 net84 VGND VGND VPWR VPWR _018_ sky130_fd_sc_hd__a22o_1
X_116_ net71 sel[4] net21 sel[3] VGND VGND VPWR VPWR _019_ sky130_fd_sc_hd__a22o_1
X_117_ net41 net83 _042_ net86 VGND VGND VPWR VPWR _020_ sky130_fd_sc_hd__a22o_1
X_118_ net41 net81 _042_ net83 VGND VGND VPWR VPWR _021_ sky130_fd_sc_hd__a22o_1
X_119_ net41 sel[7] net81 _042_ VGND VGND VPWR VPWR _022_ sky130_fd_sc_hd__a22o_1
X_120_ net89 net88 VGND VGND VPWR VPWR _043_ sky130_fd_sc_hd__nor2_1
X_121_ net42 _043_ VGND VGND VPWR VPWR _023_ sky130_fd_sc_hd__nor2_1
X_122_ net41 sel[7] net70 VGND VGND VPWR VPWR _044_ sky130_fd_sc_hd__a21oi_1
X_123_ net41 _051_ net93 _044_ net58 VGND VGND VPWR VPWR _032_ sky130_fd_sc_hd__a311oi_1
X_124_ net65 net48 net30 VGND VGND VPWR VPWR _033_ sky130_fd_sc_hd__mux2_1
X_125_ net12 net48 net90 VGND VGND VPWR VPWR _045_ sky130_fd_sc_hd__mux2i_1
X_126_ net42 sel[0] net64 VGND VGND VPWR VPWR _046_ sky130_fd_sc_hd__a21oi_1
X_127_ net30 _045_ _046_ VGND VGND VPWR VPWR _034_ sky130_fd_sc_hd__a21oi_1
X_128_ net13 net47 net91 VGND VGND VPWR VPWR _047_ sky130_fd_sc_hd__mux2i_1
X_129_ net42 sel[0] net68 VGND VGND VPWR VPWR _048_ sky130_fd_sc_hd__a21oi_1
X_130_ net30 _047_ _048_ VGND VGND VPWR VPWR _035_ sky130_fd_sc_hd__a21oi_1
X_131_ net14 net48 sel[3] VGND VGND VPWR VPWR _049_ sky130_fd_sc_hd__mux2i_1
X_132_ state[2] sel[0] net59 VGND VGND VPWR VPWR _050_ sky130_fd_sc_hd__a21oi_1
X_133_ net30 _049_ net60 VGND VGND VPWR VPWR _036_ sky130_fd_sc_hd__a21oi_1
X_134__50 clknet_2_1__leaf_clk VGND VGND VPWR VPWR net50 sky130_fd_sc_hd__inv_1
X_135__51 clknet_2_3__leaf_clk VGND VGND VPWR VPWR net51 sky130_fd_sc_hd__inv_1
X_136__52 clknet_2_1__leaf_clk VGND VGND VPWR VPWR net52 sky130_fd_sc_hd__inv_1
X_137__53 clknet_2_1__leaf_clk VGND VGND VPWR VPWR net53 sky130_fd_sc_hd__inv_1
X_138__54 clknet_2_0__leaf_clk VGND VGND VPWR VPWR net54 sky130_fd_sc_hd__inv_1
X_139__55 clknet_2_0__leaf_clk VGND VGND VPWR VPWR net55 sky130_fd_sc_hd__inv_1
X_140__56 clknet_2_0__leaf_clk VGND VGND VPWR VPWR net56 sky130_fd_sc_hd__inv_1
X_141__57 clknet_2_0__leaf_clk VGND VGND VPWR VPWR net57 sky130_fd_sc_hd__inv_1
X_142_ net50 net74 net43 VGND VGND VPWR VPWR net20 sky130_fd_sc_hd__dfstp_2
X_143_ net51 _025_ net45 VGND VGND VPWR VPWR net11 sky130_fd_sc_hd__dfstp_2
X_144_ net52 _026_ net43 VGND VGND VPWR VPWR net12 sky130_fd_sc_hd__dfstp_2
X_145_ net53 _027_ net43 VGND VGND VPWR VPWR net13 sky130_fd_sc_hd__dfstp_2
X_146_ net54 _028_ net43 VGND VGND VPWR VPWR net14 sky130_fd_sc_hd__dfstp_2
X_147_ net55 _029_ net43 VGND VGND VPWR VPWR net15 sky130_fd_sc_hd__dfstp_2
X_148_ net56 _030_ net43 VGND VGND VPWR VPWR net16 sky130_fd_sc_hd__dfstp_2
X_149_ net57 _031_ net43 VGND VGND VPWR VPWR net17 sky130_fd_sc_hd__dfstp_2
X_150_ clknet_2_2__leaf_clk _032_ net44 VGND VGND VPWR VPWR net18 sky130_fd_sc_hd__dfrtn_1
X_151_ clknet_2_3__leaf_clk _033_ net45 VGND VGND VPWR VPWR net3 sky130_fd_sc_hd__dfrtn_1
X_152_ clknet_2_3__leaf_clk _034_ net45 VGND VGND VPWR VPWR net4 sky130_fd_sc_hd__dfrtn_1
X_153_ clknet_2_3__leaf_clk _035_ net45 VGND VGND VPWR VPWR net5 sky130_fd_sc_hd__dfrtn_1
X_154_ clknet_2_3__leaf_clk _036_ net44 VGND VGND VPWR VPWR net6 sky130_fd_sc_hd__dfrtn_1
X_155_ clknet_2_2__leaf_clk _011_ net44 VGND VGND VPWR VPWR net7 sky130_fd_sc_hd__dfrtn_1
X_156_ clknet_2_2__leaf_clk _012_ net44 VGND VGND VPWR VPWR net8 sky130_fd_sc_hd__dfrtn_1
X_157_ clknet_2_2__leaf_clk net67 net44 VGND VGND VPWR VPWR net9 sky130_fd_sc_hd__dfrtn_1
X_158_ clknet_2_2__leaf_clk _014_ net44 VGND VGND VPWR VPWR net10 sky130_fd_sc_hd__dfrtn_1
X_159_ clknet_2_2__leaf_clk _015_ net44 VGND VGND VPWR VPWR net19 sky130_fd_sc_hd__dfrtn_1
X_160_ clknet_2_1__leaf_clk _016_ net45 VGND VGND VPWR VPWR sel[0] sky130_fd_sc_hd__dfrtn_1
X_161_ clknet_2_1__leaf_clk _017_ net46 VGND VGND VPWR VPWR sel[1] sky130_fd_sc_hd__dfrtn_1
X_162_ clknet_2_1__leaf_clk net85 net46 VGND VGND VPWR VPWR sel[2] sky130_fd_sc_hd__dfrtn_1
X_163_ clknet_2_1__leaf_clk net72 net46 VGND VGND VPWR VPWR sel[3] sky130_fd_sc_hd__dfrtn_1
X_164_ clknet_2_0__leaf_clk _020_ net43 VGND VGND VPWR VPWR sel[4] sky130_fd_sc_hd__dfrtn_1
X_165_ clknet_2_0__leaf_clk _021_ net43 VGND VGND VPWR VPWR sel[5] sky130_fd_sc_hd__dfrtn_1
X_166_ clknet_2_0__leaf_clk net82 net43 VGND VGND VPWR VPWR sel[6] sky130_fd_sc_hd__dfrtn_1
X_167_ clknet_2_0__leaf_clk _023_ net44 VGND VGND VPWR VPWR sel[7] sky130_fd_sc_hd__dfrtn_1
X_168_ net49 net58 net44 VGND VGND VPWR VPWR state[0] sky130_fd_sc_hd__dfstp_2
X_169_ clknet_2_3__leaf_clk _000_ net45 VGND VGND VPWR VPWR state[1] sky130_fd_sc_hd__dfrtn_1
X_170_ clknet_2_3__leaf_clk _001_ net44 VGND VGND VPWR VPWR state[2] sky130_fd_sc_hd__dfrtn_1
Xclkbuf_0_clk clk VGND VGND VPWR VPWR clknet_0_clk sky130_fd_sc_hd__clkbuf_16
Xclkbuf_2_0__f_clk clknet_0_clk VGND VGND VPWR VPWR clknet_2_0__leaf_clk sky130_fd_sc_hd__clkbuf_16
Xclkbuf_2_1__f_clk clknet_0_clk VGND VGND VPWR VPWR clknet_2_1__leaf_clk sky130_fd_sc_hd__clkbuf_16
Xclkbuf_2_2__f_clk clknet_0_clk VGND VGND VPWR VPWR clknet_2_2__leaf_clk sky130_fd_sc_hd__clkbuf_16
Xclkbuf_2_3__f_clk clknet_0_clk VGND VGND VPWR VPWR clknet_2_3__leaf_clk sky130_fd_sc_hd__clkbuf_16
Xclkload0 clknet_2_1__leaf_clk VGND VGND VPWR VPWR NC_clkload0_Y sky130_fd_sc_hd__inv_1
Xclkload1 clknet_2_2__leaf_clk VGND VGND VPWR VPWR NC_clkload1_Y sky130_fd_sc_hd__clkinv_1
Xclkload2 clknet_2_3__leaf_clk VGND VGND VPWR VPWR NC_clkload2_Y sky130_fd_sc_hd__clkinv_1
Xfanout30 _000_ VGND VGND VPWR VPWR net30 sky130_fd_sc_hd__clkdlybuf4s50_1
Xfanout41 state[2] VGND VGND VPWR VPWR net41 sky130_fd_sc_hd__clkdlybuf4s50_1
Xfanout42 state[2] VGND VGND VPWR VPWR net42 sky130_fd_sc_hd__clkdlybuf4s50_1
Xfanout43 net46 VGND VGND VPWR VPWR net43 sky130_fd_sc_hd__clkdlybuf4s50_1
Xfanout44 net46 VGND VGND VPWR VPWR net44 sky130_fd_sc_hd__clkdlybuf4s50_1
Xfanout45 net46 VGND VGND VPWR VPWR net45 sky130_fd_sc_hd__clkdlybuf4s50_1
Xfanout46 net2 VGND VGND VPWR VPWR net46 sky130_fd_sc_hd__clkdlybuf4s50_1
Xfanout47 net48 VGND VGND VPWR VPWR net47 sky130_fd_sc_hd__clkdlybuf4s50_1
Xfanout48 net1 VGND VGND VPWR VPWR net48 sky130_fd_sc_hd__clkdlybuf4s50_1
Xhold58 state[1] VGND VGND VPWR VPWR net58 sky130_fd_sc_hd__dlygate4sd3_1
Xhold59 net6 VGND VGND VPWR VPWR net59 sky130_fd_sc_hd__dlygate4sd3_1
Xhold60 _050_ VGND VGND VPWR VPWR net60 sky130_fd_sc_hd__dlygate4sd3_1
Xhold61 net7 VGND VGND VPWR VPWR net61 sky130_fd_sc_hd__dlygate4sd3_1
Xhold62 net8 VGND VGND VPWR VPWR net62 sky130_fd_sc_hd__dlygate4sd3_1
Xhold63 net10 VGND VGND VPWR VPWR net63 sky130_fd_sc_hd__dlygate4sd3_1
Xhold64 net4 VGND VGND VPWR VPWR net64 sky130_fd_sc_hd__dlygate4sd3_1
Xhold65 net3 VGND VGND VPWR VPWR net65 sky130_fd_sc_hd__dlygate4sd3_1
Xhold66 net9 VGND VGND VPWR VPWR net66 sky130_fd_sc_hd__dlygate4sd3_1
Xhold67 _013_ VGND VGND VPWR VPWR net67 sky130_fd_sc_hd__dlygate4sd3_1
Xhold68 net5 VGND VGND VPWR VPWR net68 sky130_fd_sc_hd__dlygate4sd3_1
Xhold69 net19 VGND VGND VPWR VPWR net69 sky130_fd_sc_hd__dlygate4sd3_1
Xhold70 net18 VGND VGND VPWR VPWR net70 sky130_fd_sc_hd__dlygate4sd3_1
Xhold71 state[2] VGND VGND VPWR VPWR net71 sky130_fd_sc_hd__dlygate4sd3_1
Xhold72 _019_ VGND VGND VPWR VPWR net72 sky130_fd_sc_hd__dlygate4sd3_1
Xhold73 net20 VGND VGND VPWR VPWR net73 sky130_fd_sc_hd__dlygate4sd3_1
Xhold74 _024_ VGND VGND VPWR VPWR net74 sky130_fd_sc_hd__dlygate4sd3_1
Xhold75 net13 VGND VGND VPWR VPWR net75 sky130_fd_sc_hd__dlygate4sd3_1
Xhold76 net14 VGND VGND VPWR VPWR net76 sky130_fd_sc_hd__dlygate4sd3_1
Xhold77 net16 VGND VGND VPWR VPWR net77 sky130_fd_sc_hd__dlygate4sd3_1
Xhold78 net15 VGND VGND VPWR VPWR net78 sky130_fd_sc_hd__dlygate4sd3_1
Xhold79 net17 VGND VGND VPWR VPWR net79 sky130_fd_sc_hd__dlygate4sd3_1
Xhold80 net12 VGND VGND VPWR VPWR net80 sky130_fd_sc_hd__dlygate4sd3_1
Xhold81 sel[6] VGND VGND VPWR VPWR net81 sky130_fd_sc_hd__dlygate4sd3_1
Xhold82 _022_ VGND VGND VPWR VPWR net82 sky130_fd_sc_hd__dlygate4sd3_1
Xhold83 sel[5] VGND VGND VPWR VPWR net83 sky130_fd_sc_hd__dlygate4sd3_1
Xhold84 sel[2] VGND VGND VPWR VPWR net84 sky130_fd_sc_hd__dlygate4sd3_1
Xhold85 _018_ VGND VGND VPWR VPWR net85 sky130_fd_sc_hd__dlygate4sd3_1
Xhold86 sel[4] VGND VGND VPWR VPWR net86 sky130_fd_sc_hd__dlygate4sd3_1
Xhold87 sel[1] VGND VGND VPWR VPWR net87 sky130_fd_sc_hd__dlygate4sd3_1
Xhold88 state[0] VGND VGND VPWR VPWR net88 sky130_fd_sc_hd__dlygate4sd3_1
Xhold89 sel[7] VGND VGND VPWR VPWR net89 sky130_fd_sc_hd__dlygate4sd3_1
Xhold90 sel[1] VGND VGND VPWR VPWR net90 sky130_fd_sc_hd__dlygate4sd3_1
Xhold91 sel[2] VGND VGND VPWR VPWR net91 sky130_fd_sc_hd__dlygate4sd3_1
Xhold92 sel[5] VGND VGND VPWR VPWR net92 sky130_fd_sc_hd__dlygate4sd3_1
Xhold93 sel[7] VGND VGND VPWR VPWR net93 sky130_fd_sc_hd__dlygate4sd3_1
Xinput1 comp VGND VGND VPWR VPWR net1 sky130_fd_sc_hd__buf_2
Xinput2 rst_n VGND VGND VPWR VPWR net2 sky130_fd_sc_hd__buf_2
Xmax_cap21 _042_ VGND VGND VPWR VPWR net21 sky130_fd_sc_hd__clkbuf_2
Xoutput10 net10 VGND VGND VPWR VPWR net40 sky130_fd_sc_hd__buf_4
Xoutput11 net11 VGND VGND VPWR VPWR net29 sky130_fd_sc_hd__buf_4
Xoutput12 net12 VGND VGND VPWR VPWR net28 sky130_fd_sc_hd__buf_4
Xoutput13 net13 VGND VGND VPWR VPWR net27 sky130_fd_sc_hd__buf_4
Xoutput14 net14 VGND VGND VPWR VPWR net26 sky130_fd_sc_hd__buf_4
Xoutput15 net15 VGND VGND VPWR VPWR net25 sky130_fd_sc_hd__buf_4
Xoutput16 net16 VGND VGND VPWR VPWR net24 sky130_fd_sc_hd__buf_4
Xoutput17 net17 VGND VGND VPWR VPWR net23 sky130_fd_sc_hd__buf_4
Xoutput18 net18 VGND VGND VPWR VPWR net39 sky130_fd_sc_hd__buf_4
Xoutput19 net19 VGND VGND VPWR VPWR net38 sky130_fd_sc_hd__buf_4
Xoutput20 net20 VGND VGND VPWR VPWR net22 sky130_fd_sc_hd__buf_4
Xoutput3 net3 VGND VGND VPWR VPWR net37 sky130_fd_sc_hd__buf_4
Xoutput4 net4 VGND VGND VPWR VPWR net36 sky130_fd_sc_hd__buf_4
Xoutput5 net5 VGND VGND VPWR VPWR net35 sky130_fd_sc_hd__buf_4
Xoutput6 net6 VGND VGND VPWR VPWR net34 sky130_fd_sc_hd__buf_4
Xoutput7 net7 VGND VGND VPWR VPWR net33 sky130_fd_sc_hd__buf_4
Xoutput8 net8 VGND VGND VPWR VPWR net32 sky130_fd_sc_hd__buf_4
Xoutput9 net9 VGND VGND VPWR VPWR net31 sky130_fd_sc_hd__buf_4
Xwire22 net22 VGND VGND VPWR VPWR phi sky130_fd_sc_hd__buf_16
Xwire23 net23 VGND VGND VPWR VPWR dn[6] sky130_fd_sc_hd__buf_16
Xwire24 net24 VGND VGND VPWR VPWR dn[5] sky130_fd_sc_hd__buf_16
Xwire25 net25 VGND VGND VPWR VPWR dn[4] sky130_fd_sc_hd__buf_16
Xwire26 net26 VGND VGND VPWR VPWR dn[3] sky130_fd_sc_hd__buf_16
Xwire27 net27 VGND VGND VPWR VPWR dn[2] sky130_fd_sc_hd__buf_16
Xwire28 net28 VGND VGND VPWR VPWR dn[1] sky130_fd_sc_hd__buf_16
Xwire29 net29 VGND VGND VPWR VPWR dn[0] sky130_fd_sc_hd__buf_16
Xwire31 net31 VGND VGND VPWR VPWR code[6] sky130_fd_sc_hd__buf_16
Xwire32 net32 VGND VGND VPWR VPWR code[5] sky130_fd_sc_hd__buf_16
Xwire33 net33 VGND VGND VPWR VPWR code[4] sky130_fd_sc_hd__buf_16
Xwire34 net34 VGND VGND VPWR VPWR code[3] sky130_fd_sc_hd__buf_16
Xwire35 net35 VGND VGND VPWR VPWR code[2] sky130_fd_sc_hd__buf_16
Xwire36 net36 VGND VGND VPWR VPWR code[1] sky130_fd_sc_hd__buf_16
Xwire37 net37 VGND VGND VPWR VPWR code[0] sky130_fd_sc_hd__buf_16
Xwire38 net38 VGND VGND VPWR VPWR done sky130_fd_sc_hd__buf_16
Xwire39 net39 VGND VGND VPWR VPWR dn[7] sky130_fd_sc_hd__buf_16
Xwire40 net40 VGND VGND VPWR VPWR code[7] sky130_fd_sc_hd__buf_16
.ends
