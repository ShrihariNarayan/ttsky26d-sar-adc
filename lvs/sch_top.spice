** sch_path: /foss/designs/ttsky26d-sar-adc/xschem/adc_core.sch
.subckt adc_core phi clk vin comp dn7 VDD dn6 dn5 VSS dn4 dn3 dn2 dn1 Vref dn0
*.PININFO dn7:I dn6:I dn5:I dn4:I dn3:I dn2:I dn1:I dn0:I VDD:B VSS:B Vref:B comp:O phi:I clk:I vin:I
x2 phi VDD VSS vin vtop bootstrap_switch
x4 Vref vcm VSS vcm_gen
x1 VDD dn7 dn6 dn5 VSS dn4 dn3 vtop dn2 dn1 Vref dn0 cdac
x5 vtop VDD vcm clk VSS comp compn comparator
XMCdec VSS Vref VSS VSS sky130_fd_pr__nfet_01v8 L=5 W=240 nf=24
.ends

* expanding   symbol:  bootstrap_switch.sym # of pins=5
** sym_path: /foss/designs/ttsky26d-sar-adc/xschem/bootstrap_switch.sym
** sch_path: /foss/designs/ttsky26d-sar-adc/xschem/bootstrap_switch.sch
.subckt bootstrap_switch phi VDD VSS vin vout
*.PININFO VDD:B VSS:B vout:O phi:I vin:I
XM8 X N P P sky130_fd_pr__pfet_01v8 L=0.15 W=2 nf=1
XM11 vin X vout VSS sky130_fd_pr__nfet_01v8 L=0.15 W=1 nf=1
XC2 P B sky130_fd_pr__cap_mim_m3_1 W=11 L=11 m=2
XM9 B X vin VSS sky130_fd_pr__nfet_01v8 L=0.15 W=2 nf=1
XM12 VSS phi_b B VSS sky130_fd_pr__nfet_01v8 L=0.15 W=1 nf=1
XM14 X VDD net1 VSS sky130_fd_pr__nfet_01v8 L=0.15 W=4 nf=1
XM3 P X VDD P sky130_fd_pr__pfet_01v8 L=0.15 W=2 nf=1
XM10 net1 phi_b VSS VSS sky130_fd_pr__nfet_01v8 L=0.15 W=1 nf=1
XM15 N phi B VSS sky130_fd_pr__nfet_01v8 L=0.15 W=1 nf=1
XM16 N phi VDD VDD sky130_fd_pr__pfet_01v8 L=0.15 W=1 nf=1
XMIN phi_b phi VSS VSS sky130_fd_pr__nfet_01v8 L=0.15 W=1 nf=1
XMIP phi_b phi VDD VDD sky130_fd_pr__pfet_01v8 L=0.15 W=2 nf=1
.ends

* expanding   symbol:  vcm_gen.sym # of pins=3
** sym_path: /foss/designs/ttsky26d-sar-adc/xschem/vcm_gen.sym
** sch_path: /foss/designs/ttsky26d-sar-adc/xschem/vcm_gen.sch
.subckt vcm_gen Vref vcm VSS
*.PININFO Vref:B vcm:B VSS:B
XR1 vcm Vref VSS sky130_fd_pr__res_xhigh_po_1p41 L=36 mult=1
XR2 VSS vcm VSS sky130_fd_pr__res_xhigh_po_1p41 L=36 mult=1
XCcm vcm VSS sky130_fd_pr__cap_mim_m3_1 W=22 L=22 m=2
.ends

* expanding   symbol:  cdac.sym # of pins=12
** sym_path: /foss/designs/ttsky26d-sar-adc/xschem/cdac.sym
** sch_path: /foss/designs/ttsky26d-sar-adc/xschem/cdac.sch
.subckt cdac VDD dn7 dn6 dn5 VSS dn4 dn3 vtop dn2 dn1 Vref dn0
*.PININFO dn7:I dn6:I dn5:I dn4:I dn3:I dn2:I dn1:I dn0:I VDD:B VSS:B vtop:B Vref:B
XMN7 b7 dn7 VSS VSS sky130_fd_pr__nfet_01v8 L=0.15 W=16 nf=4
XMP7 b7 dn7 Vref Vref sky130_fd_pr__pfet_01v8_lvt L=0.35 W=32 nf=8
XC7 vtop b7 sky130_fd_pr__cap_mim_m3_1 W=2 L=2 m=128
XMN6 b6 dn6 VSS VSS sky130_fd_pr__nfet_01v8 L=0.15 W=8 nf=2
XMP6 b6 dn6 Vref Vref sky130_fd_pr__pfet_01v8_lvt L=0.35 W=16 nf=4
XC6 vtop b6 sky130_fd_pr__cap_mim_m3_1 W=2 L=2 m=64
XMN5 b5 dn5 VSS VSS sky130_fd_pr__nfet_01v8 L=0.15 W=4 nf=1
XMP5 b5 dn5 Vref Vref sky130_fd_pr__pfet_01v8_lvt L=0.35 W=8 nf=2
XC5 vtop b5 sky130_fd_pr__cap_mim_m3_1 W=2 L=2 m=32
XMN4 b4 dn4 VSS VSS sky130_fd_pr__nfet_01v8 L=0.15 W=2 nf=1
XMP4 b4 dn4 Vref Vref sky130_fd_pr__pfet_01v8_lvt L=0.35 W=4 nf=1
XC4 vtop b4 sky130_fd_pr__cap_mim_m3_1 W=2 L=2 m=16
XMN3 b3 dn3 VSS VSS sky130_fd_pr__nfet_01v8 L=0.15 W=0.5 nf=1
XMP3 b3 dn3 Vref Vref sky130_fd_pr__pfet_01v8_lvt L=0.35 W=1 nf=1
XC3 vtop b3 sky130_fd_pr__cap_mim_m3_1 W=2 L=2 m=8
XMN2 b2 dn2 VSS VSS sky130_fd_pr__nfet_01v8 L=0.15 W=0.5 nf=1
XMP2 b2 dn2 Vref Vref sky130_fd_pr__pfet_01v8_lvt L=0.35 W=1 nf=1
XC2 vtop b2 sky130_fd_pr__cap_mim_m3_1 W=2 L=2 m=4
XMN1 b1 dn1 VSS VSS sky130_fd_pr__nfet_01v8 L=0.15 W=0.5 nf=1
XMP1 b1 dn1 Vref Vref sky130_fd_pr__pfet_01v8_lvt L=0.35 W=1 nf=1
XC1 vtop b1 sky130_fd_pr__cap_mim_m3_1 W=2 L=2 m=2
XMN0 b0 dn0 VSS VSS sky130_fd_pr__nfet_01v8 L=0.15 W=0.5 nf=1
XMP0 b0 dn0 Vref Vref sky130_fd_pr__pfet_01v8_lvt L=0.35 W=1 nf=1
XC0 vtop b0 sky130_fd_pr__cap_mim_m3_1 W=2 L=2
XCdmy vtop VSS sky130_fd_pr__cap_mim_m3_1 W=2 L=2
.ends

* expanding   symbol:  comparator.sym # of pins=7
** sym_path: /foss/designs/ttsky26d-sar-adc/xschem/comparator.sym
** sch_path: /foss/designs/ttsky26d-sar-adc/xschem/comparator.sch
.subckt comparator inp VDD inn clk VSS outp outn
*.PININFO inp:I inn:I clk:I outp:O outn:O VDD:B VSS:B
x1 inp VDD inn clk VSS X Y comparator_sa
XMI1N Yb Y VSS VSS sky130_fd_pr__nfet_01v8 L=0.15 W=1 nf=1
XMI1P Yb Y VDD VDD sky130_fd_pr__pfet_01v8 L=0.15 W=2 nf=1
XMI2N Xb X VSS VSS sky130_fd_pr__nfet_01v8 L=0.15 W=1 nf=1
XMI2P Xb X VDD VDD sky130_fd_pr__pfet_01v8 L=0.15 W=2 nf=1
XMA1 outp Yb VDD VDD sky130_fd_pr__pfet_01v8 L=0.15 W=1 nf=1
XMA2 outp outn VDD VDD sky130_fd_pr__pfet_01v8 L=0.15 W=1 nf=1
XMA3 outp Yb na VSS sky130_fd_pr__nfet_01v8 L=0.15 W=2 nf=1
XMA4 na outn VSS VSS sky130_fd_pr__nfet_01v8 L=0.15 W=2 nf=1
XMB1 outn Xb VDD VDD sky130_fd_pr__pfet_01v8 L=0.15 W=1 nf=1
XMB2 outn outp VDD VDD sky130_fd_pr__pfet_01v8 L=0.15 W=1 nf=1
XMB3 outn Xb nb VSS sky130_fd_pr__nfet_01v8 L=0.15 W=2 nf=1
XMB4 nb outp VSS VSS sky130_fd_pr__nfet_01v8 L=0.15 W=2 nf=1
.ends

* expanding   symbol:  comparator_sa.sym # of pins=7
** sym_path: /foss/designs/ttsky26d-sar-adc/xschem/comparator_sa.sym
** sch_path: /foss/designs/ttsky26d-sar-adc/xschem/comparator_sa.sch
.subckt comparator_sa inp VDD inn clk VSS X Y
*.PININFO inp:I inn:I clk:I X:O Y:O VDD:B VSS:B
XM7 T ckb VDD VDD sky130_fd_pr__pfet_01v8 L=0.15 W=4 nf=1
XM1 P inp T T sky130_fd_pr__pfet_01v8 L=0.5 W=8 nf=4
XM2 Q inn T T sky130_fd_pr__pfet_01v8 L=0.5 W=8 nf=4
XM3 X Y P VDD sky130_fd_pr__pfet_01v8 L=0.15 W=2 nf=1
XM4 Y X Q VDD sky130_fd_pr__pfet_01v8 L=0.15 W=2 nf=1
XM6 Y X VSS VSS sky130_fd_pr__nfet_01v8 L=0.15 W=1 nf=1
XM5 X Y VSS VSS sky130_fd_pr__nfet_01v8 L=0.15 W=1 nf=1
XS4 Y ckb VSS VSS sky130_fd_pr__nfet_01v8 L=0.6 W=2 nf=1
XS2 Q ckb VSS VSS sky130_fd_pr__nfet_01v8 L=0.6 W=2 nf=1
XS3 X ckb VSS VSS sky130_fd_pr__nfet_01v8 L=0.6 W=2 nf=1
XS1 P ckb VSS VSS sky130_fd_pr__nfet_01v8 L=0.6 W=2 nf=1
XMIN ckb clk VSS VSS sky130_fd_pr__nfet_01v8 L=0.15 W=1 nf=1
XMIP ckb clk VDD VDD sky130_fd_pr__pfet_01v8 L=0.15 W=2 nf=1
.ends

.subckt sar_logic VGND VPWR clk code[0] code[1] code[2] code[3] code[4] code[5] code[6] code[7] comp dn[0] dn[1] dn[2] dn[3] dn[4] dn[5] dn[6] dn[7] done phi rst_n
.ends
.subckt tt_um_shriharinarayan_sar_adc clk ena rst_n ua[0] ua[1] ua[2] ua[3] ua[4] ua[5] ua[6] ua[7] ui_in[0] ui_in[1] ui_in[2] ui_in[3] ui_in[4] ui_in[5] ui_in[6] ui_in[7] uio_in[0] uio_in[1] uio_in[2] uio_in[3] uio_in[4] uio_in[5] uio_in[6] uio_in[7] uio_out[0] uo_out[0] uo_out[1] uo_out[2] uo_out[3] uo_out[4] uo_out[5] uo_out[6] uo_out[7] VDPWR VGND
xcore phi clk ua[0] comp dn7 VDPWR dn6 dn5 VGND dn4 dn3 dn2 dn1 ua[1] dn0 adc_core
xlogic VGND VDPWR clk uo_out[0] uo_out[1] uo_out[2] uo_out[3] uo_out[4] uo_out[5] uo_out[6] uo_out[7] comp dn0 dn1 dn2 dn3 dn4 dn5 dn6 dn7 uio_out[0] phi rst_n sar_logic
.ends
.end
